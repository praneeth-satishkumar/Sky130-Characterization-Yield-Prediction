* Sky130 ring oscillator testbench

.lib "/foss/pdks/ciel/sky130/versions/7b70722e33c03fcb5dabcf4d479fb0822d9251c9/sky130A/libs.tech/ngspice/sky130.lib.spice" tt

VDD vdd 0 1.8
VEN en 0 1.8

* Ring oscillator cells would be instantiated here
* using Sky130 standard-cell SPICE subcircuits.

.tran 1p 200n
.control
run
plot v(ro_out)
.endc

.end
