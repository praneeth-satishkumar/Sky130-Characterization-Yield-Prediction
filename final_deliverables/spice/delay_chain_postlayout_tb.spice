* Post-layout extracted Sky130 delay-chain simulation - TT

.lib "/foss/pdks/ciel/sky130/versions/7b70722e33c03fcb5dabcf4d479fb0822d9251c9/sky130A/libs.tech/ngspice/sky130.lib.spice" tt
.include "delay_chain_physical_top.spice"

VDD VPWR 0 1.8
VSS VGND 0 0

VIN in 0 PULSE(0 1.8 1n 20p 20p 2n 4n)

* Check pin order:
* VGND VPWR in out
XDELAY VGND VPWR in out delay_chain_physical_top

.tran 5p 10n

.measure tran rise_delay TRIG v(in) VAL=0.9 RISE=1 TARG v(out) VAL=0.9 RISE=1
.measure tran fall_delay TRIG v(in) VAL=0.9 FALL=1 TARG v(out) VAL=0.9 FALL=1

.control
set filetype=ascii
set num_threads=1
save v(in) v(out)
run
plot v(in) v(out)
print rise_delay
print fall_delay
.endc

.end
