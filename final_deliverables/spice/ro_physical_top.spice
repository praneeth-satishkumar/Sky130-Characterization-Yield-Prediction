* NGSPICE file created from ro_physical_top.ext - technology: sky130A

.subckt sky130_fd_sc_hd__decap_3 VPWR VGND VPB VNB
X0 VPWR VGND VPWR VPB sky130_fd_pr__pfet_01v8_hvt ad=0.2262 pd=2.26 as=0.4524 ps=4.52 w=0.87 l=0.59
X1 VGND VPWR VGND VNB sky130_fd_pr__nfet_01v8 ad=0.143 pd=1.62 as=0.286 ps=3.24 w=0.55 l=0.59
C0 VGND VPWR 0.353f
C1 VPB VPWR 0.06352f
C2 VPB VGND 0.08022f
C3 VPWR VNB 0.40327f
C4 VGND VNB 0.36155f
C5 VPB VNB 0.33898f
.ends

.subckt sky130_fd_sc_hd__nand2_1 VPB VNB VGND VPWR A Y B a_113_47#
X0 VPWR A Y VPB sky130_fd_pr__pfet_01v8_hvt ad=0.26 pd=2.52 as=0.135 ps=1.27 w=1 l=0.15
X1 Y A a_113_47# VNB sky130_fd_pr__nfet_01v8 ad=0.169 pd=1.82 as=0.08775 ps=0.92 w=0.65 l=0.15
X2 a_113_47# B VGND VNB sky130_fd_pr__nfet_01v8 ad=0.08775 pd=0.92 as=0.169 ps=1.82 w=0.65 l=0.15
X3 Y B VPWR VPB sky130_fd_pr__pfet_01v8_hvt ad=0.135 pd=1.27 as=0.26 ps=2.52 w=1 l=0.15
C0 VGND B 0.0544f
C1 VPWR VGND 0.03219f
C2 VPB VGND 0.0044f
C3 a_113_47# VGND 0.00201f
C4 Y B 0.04807f
C5 A VGND 0.00949f
C6 VPWR Y 0.21151f
C7 VPB Y 0.00618f
C8 a_113_47# Y 0.00937f
C9 VPWR B 0.05148f
C10 A Y 0.08548f
C11 VPB B 0.03907f
C12 VPB VPWR 0.05574f
C13 a_113_47# VPWR 0
C14 A B 0.05096f
C15 A VPWR 0.04807f
C16 Y VGND 0.139f
C17 VPB A 0.03788f
C18 VGND VNB 0.23154f
C19 Y VNB 0.05566f
C20 VPWR VNB 0.24021f
C21 A VNB 0.10995f
C22 B VNB 0.11267f
C23 VPB VNB 0.33898f
.ends

.subckt sky130_fd_sc_hd__clkdlybuf4s25_1 VNB VPB VPWR VGND A X a_244_47# a_355_47#
+ a_27_47#
X0 a_244_47# a_27_47# VPWR VPB sky130_fd_pr__pfet_01v8_hvt ad=0.2173 pd=2.17 as=0.19265 ps=1.415 w=0.82 l=0.25
X1 VPWR a_244_47# a_355_47# VPB sky130_fd_pr__pfet_01v8_hvt ad=0.2726 pd=1.61 as=0.2173 ps=2.17 w=0.82 l=0.25
X2 X a_355_47# VPWR VPB sky130_fd_pr__pfet_01v8_hvt ad=0.495 pd=2.99 as=0.2726 ps=1.61 w=1 l=0.15
X3 VPWR A a_27_47# VPB sky130_fd_pr__pfet_01v8_hvt ad=0.19265 pd=1.415 as=0.27 ps=2.54 w=1 l=0.15
X4 VGND A a_27_47# VNB sky130_fd_pr__nfet_01v8 ad=0.1228 pd=1.065 as=0.1134 ps=1.38 w=0.42 l=0.15
X5 VGND a_244_47# a_355_47# VNB sky130_fd_pr__nfet_01v8 ad=0.1856 pd=1.26 as=0.17225 ps=1.83 w=0.65 l=0.25
X6 X a_355_47# VGND VNB sky130_fd_pr__nfet_01v8 ad=0.2079 pd=1.83 as=0.1856 ps=1.26 w=0.42 l=0.15
X7 a_244_47# a_27_47# VGND VNB sky130_fd_pr__nfet_01v8 ad=0.17225 pd=1.83 as=0.1228 ps=1.065 w=0.65 l=0.25
C0 VPWR X 0.13117f
C1 VPB VPWR 0.09181f
C2 A VGND 0.01777f
C3 a_355_47# VPWR 0.17543f
C4 a_244_47# VPWR 0.13909f
C5 a_27_47# VPWR 0.18008f
C6 VPB A 0.03819f
C7 VGND X 0.10651f
C8 VPB VGND 0.00815f
C9 a_355_47# A 0.00204f
C10 a_244_47# A 0.00176f
C11 a_27_47# A 0.17892f
C12 a_355_47# VGND 0.15079f
C13 a_244_47# VGND 0.1171f
C14 a_27_47# VGND 0.1493f
C15 VPB X 0.01394f
C16 a_355_47# X 0.08925f
C17 a_244_47# X 0.00177f
C18 a_355_47# VPB 0.0494f
C19 a_244_47# VPB 0.09475f
C20 a_27_47# VPB 0.07658f
C21 a_244_47# a_355_47# 0.34134f
C22 a_27_47# a_355_47# 0
C23 a_27_47# a_244_47# 0.11296f
C24 A VPWR 0.0192f
C25 VPWR VGND 0.07516f
C26 VGND VNB 0.43338f
C27 X VNB 0.10191f
C28 VPWR VNB 0.35021f
C29 A VNB 0.13453f
C30 VPB VNB 0.78196f
C31 a_355_47# VNB 0.12797f
C32 a_244_47# VNB 0.13382f
C33 a_27_47# VNB 0.17294f
.ends

.subckt sky130_fd_sc_hd__inv_1 VPB VNB VGND VPWR A Y
X0 Y A VGND VNB sky130_fd_pr__nfet_01v8 ad=0.169 pd=1.82 as=0.169 ps=1.82 w=0.65 l=0.15
X1 Y A VPWR VPB sky130_fd_pr__pfet_01v8_hvt ad=0.26 pd=2.52 as=0.26 ps=2.52 w=1 l=0.15
C0 VPWR VGND 0.03401f
C1 VPB VGND 0.01319f
C2 VPWR Y 0.12759f
C3 A VGND 0.04768f
C4 VPB Y 0.01774f
C5 A Y 0.0476f
C6 VPB VPWR 0.06649f
C7 A VPWR 0.04571f
C8 Y VGND 0.09986f
C9 VPB A 0.04506f
C10 VGND VNB 0.24421f
C11 Y VNB 0.0961f
C12 VPWR VNB 0.20582f
C13 A VNB 0.13301f
C14 VPB VNB 0.33898f
.ends

.subckt sky130_fd_sc_hd__buf_2 VPWR VGND X A VPB VNB a_27_47#
X0 VPWR a_27_47# X VPB sky130_fd_pr__pfet_01v8_hvt ad=0.265 pd=2.53 as=0.135 ps=1.27 w=1 l=0.15
X1 X a_27_47# VPWR VPB sky130_fd_pr__pfet_01v8_hvt ad=0.135 pd=1.27 as=0.149 ps=1.325 w=1 l=0.15
X2 VPWR A a_27_47# VPB sky130_fd_pr__pfet_01v8_hvt ad=0.149 pd=1.325 as=0.1664 ps=1.8 w=0.64 l=0.15
X3 X a_27_47# VGND VNB sky130_fd_pr__nfet_01v8 ad=0.08775 pd=0.92 as=0.097 ps=0.975 w=0.65 l=0.15
X4 VGND a_27_47# X VNB sky130_fd_pr__nfet_01v8 ad=0.17225 pd=1.83 as=0.08775 ps=0.92 w=0.65 l=0.15
X5 VGND A a_27_47# VNB sky130_fd_pr__nfet_01v8 ad=0.097 pd=0.975 as=0.1092 ps=1.36 w=0.42 l=0.15
C0 A X 0.00306f
C1 VPWR VGND 0.05175f
C2 a_27_47# X 0.14884f
C3 VPB X 0.00443f
C4 A VPWR 0.02211f
C5 A VGND 0.01989f
C6 a_27_47# VPWR 0.15768f
C7 a_27_47# VGND 0.13074f
C8 VPB VPWR 0.058f
C9 VPB VGND 0.00642f
C10 a_27_47# A 0.16236f
C11 VPB A 0.06973f
C12 VPWR X 0.1691f
C13 a_27_47# VPB 0.07868f
C14 X VGND 0.11137f
C15 VGND VNB 0.28216f
C16 X VNB 0.0215f
C17 VPWR VNB 0.24432f
C18 A VNB 0.15431f
C19 VPB VNB 0.42757f
C20 a_27_47# VNB 0.2125f
.ends

.subckt ro_physical_top VGND VPWR enable ro_out
XFILLER_22_177 VPWR VGND VPWR VGND sky130_fd_sc_hd__decap_3
XFILLER_22_144 VPWR VGND VPWR VGND sky130_fd_sc_hd__decap_3
XFILLER_22_133 VPWR VGND VPWR VGND sky130_fd_sc_hd__decap_3
XFILLER_22_100 VPWR VGND VPWR VGND sky130_fd_sc_hd__decap_3
XFILLER_26_85 VPWR VGND VPWR VGND sky130_fd_sc_hd__decap_3
XFILLER_26_74 VPWR VGND VPWR VGND sky130_fd_sc_hd__decap_3
XFILLER_26_41 VPWR VGND VPWR VGND sky130_fd_sc_hd__decap_3
XFILLER_13_122 VPWR VGND VPWR VGND sky130_fd_sc_hd__decap_3
XFILLER_9_137 VPWR VGND VPWR VGND sky130_fd_sc_hd__decap_3
XFILLER_13_155 VPWR VGND VPWR VGND sky130_fd_sc_hd__decap_3
XFILLER_3_45 VPWR VGND VPWR VGND sky130_fd_sc_hd__decap_3
XFILLER_3_12 VPWR VGND VPWR VGND sky130_fd_sc_hd__decap_3
XFILLER_3_78 VPWR VGND VPWR VGND sky130_fd_sc_hd__decap_3
XFILLER_6_118 VPWR VGND VPWR VGND sky130_fd_sc_hd__decap_3
XFILLER_10_103 VPWR VGND VPWR VGND sky130_fd_sc_hd__decap_3
XFILLER_10_136 VPWR VGND VPWR VGND sky130_fd_sc_hd__decap_3
XFILLER_10_147 VPWR VGND VPWR VGND sky130_fd_sc_hd__decap_3
XFILLER_12_21 VPWR VGND VPWR VGND sky130_fd_sc_hd__decap_3
XFILLER_12_32 VPWR VGND VPWR VGND sky130_fd_sc_hd__decap_3
XFILLER_12_65 VPWR VGND VPWR VGND sky130_fd_sc_hd__decap_3
XFILLER_5_140 VPWR VGND VPWR VGND sky130_fd_sc_hd__decap_3
XFILLER_5_184 VPWR VGND VPWR VGND sky130_fd_sc_hd__decap_3
XFILLER_23_75 VPWR VGND VPWR VGND sky130_fd_sc_hd__decap_3
XFILLER_23_42 VPWR VGND VPWR VGND sky130_fd_sc_hd__decap_3
XFILLER_2_165 VPWR VGND VPWR VGND sky130_fd_sc_hd__decap_3
XFILLER_2_110 VPWR VGND VPWR VGND sky130_fd_sc_hd__decap_3
XFILLER_0_24 VPWR VGND VPWR VGND sky130_fd_sc_hd__decap_3
XFILLER_0_35 VPWR VGND VPWR VGND sky130_fd_sc_hd__decap_3
XFILLER_0_57 VPWR VGND VPWR VGND sky130_fd_sc_hd__decap_3
XFILLER_17_9 VPWR VGND VPWR VGND sky130_fd_sc_hd__decap_3
XFILLER_9_33 VPWR VGND VPWR VGND sky130_fd_sc_hd__decap_3
XFILLER_9_66 VPWR VGND VPWR VGND sky130_fd_sc_hd__decap_3
XFILLER_9_99 VPWR VGND VPWR VGND sky130_fd_sc_hd__decap_3
XPHY_EDGE_ROW_8_Left_36 VPWR VGND VPWR VGND sky130_fd_sc_hd__decap_3
XFILLER_18_53 VPWR VGND VPWR VGND sky130_fd_sc_hd__decap_3
XFILLER_18_97 VPWR VGND VPWR VGND sky130_fd_sc_hd__decap_3
XFILLER_15_6 VPWR VGND VPWR VGND sky130_fd_sc_hd__decap_3
XFILLER_20_21 VPWR VGND VPWR VGND sky130_fd_sc_hd__decap_3
XFILLER_20_32 VPWR VGND VPWR VGND sky130_fd_sc_hd__decap_3
XFILLER_20_65 VPWR VGND VPWR VGND sky130_fd_sc_hd__decap_3
XFILLER_6_12 VPWR VGND VPWR VGND sky130_fd_sc_hd__decap_3
XFILLER_6_56 VPWR VGND VPWR VGND sky130_fd_sc_hd__decap_3
XFILLER_26_109 VPWR VGND VPWR VGND sky130_fd_sc_hd__decap_3
XFILLER_13_3 VPWR VGND VPWR VGND sky130_fd_sc_hd__decap_3
XFILLER_19_161 VPWR VGND VPWR VGND sky130_fd_sc_hd__decap_3
XFILLER_19_172 VPWR VGND VPWR VGND sky130_fd_sc_hd__decap_3
XFILLER_25_175 VPWR VGND VPWR VGND sky130_fd_sc_hd__decap_3
XFILLER_25_164 VPWR VGND VPWR VGND sky130_fd_sc_hd__decap_3
XFILLER_25_131 VPWR VGND VPWR VGND sky130_fd_sc_hd__decap_3
XFILLER_15_21 VPWR VGND VPWR VGND sky130_fd_sc_hd__decap_3
XFILLER_15_87 VPWR VGND VPWR VGND sky130_fd_sc_hd__decap_3
XFILLER_16_153 VPWR VGND VPWR VGND sky130_fd_sc_hd__decap_3
XFILLER_16_186 VPWR VGND VPWR VGND sky130_fd_sc_hd__decap_3
XFILLER_22_156 VPWR VGND VPWR VGND sky130_fd_sc_hd__decap_3
XFILLER_22_112 VPWR VGND VPWR VGND sky130_fd_sc_hd__decap_3
XFILLER_26_97 VPWR VGND VPWR VGND sky130_fd_sc_hd__decap_3
XFILLER_26_53 VPWR VGND VPWR VGND sky130_fd_sc_hd__decap_3
XFILLER_9_105 VPWR VGND VPWR VGND sky130_fd_sc_hd__decap_3
XFILLER_9_116 VPWR VGND VPWR VGND sky130_fd_sc_hd__decap_3
XFILLER_13_134 VPWR VGND VPWR VGND sky130_fd_sc_hd__decap_3
XFILLER_9_149 VPWR VGND VPWR VGND sky130_fd_sc_hd__decap_3
XFILLER_13_178 VPWR VGND VPWR VGND sky130_fd_sc_hd__decap_3
XPHY_EDGE_ROW_21_Left_49 VPWR VGND VPWR VGND sky130_fd_sc_hd__decap_3
XFILLER_3_57 VPWR VGND VPWR VGND sky130_fd_sc_hd__decap_3
XFILLER_3_24 VPWR VGND VPWR VGND sky130_fd_sc_hd__decap_3
XFILLER_8_171 VPWR VGND VPWR VGND sky130_fd_sc_hd__decap_3
XFILLER_10_115 VPWR VGND VPWR VGND sky130_fd_sc_hd__decap_3
XFILLER_10_159 VPWR VGND VPWR VGND sky130_fd_sc_hd__decap_3
XFILLER_12_44 VPWR VGND VPWR VGND sky130_fd_sc_hd__decap_3
XFILLER_12_77 VPWR VGND VPWR VGND sky130_fd_sc_hd__decap_3
XFILLER_12_88 VPWR VGND VPWR VGND sky130_fd_sc_hd__decap_3
XFILLER_5_152 VPWR VGND VPWR VGND sky130_fd_sc_hd__decap_3
XPHY_EDGE_ROW_12_Right_12 VPWR VGND VPWR VGND sky130_fd_sc_hd__decap_3
XPHY_EDGE_ROW_21_Right_21 VPWR VGND VPWR VGND sky130_fd_sc_hd__decap_3
XFILLER_23_21 VPWR VGND VPWR VGND sky130_fd_sc_hd__decap_3
Xu_nand VPWR VGND VGND VPWR u_nand/A u_nand/Y u_buf/A u_nand/a_113_47# sky130_fd_sc_hd__nand2_1
XFILLER_23_87 VPWR VGND VPWR VGND sky130_fd_sc_hd__decap_3
XFILLER_2_122 VPWR VGND VPWR VGND sky130_fd_sc_hd__decap_3
XFILLER_2_177 VPWR VGND VPWR VGND sky130_fd_sc_hd__decap_3
XFILLER_2_144 VPWR VGND VPWR VGND sky130_fd_sc_hd__decap_3
XFILLER_0_47 VPWR VGND VPWR VGND sky130_fd_sc_hd__decap_3
XFILLER_0_69 VPWR VGND VPWR VGND sky130_fd_sc_hd__decap_3
XFILLER_9_12 VPWR VGND VPWR VGND sky130_fd_sc_hd__decap_3
XFILLER_9_45 VPWR VGND VPWR VGND sky130_fd_sc_hd__decap_3
XFILLER_9_78 VPWR VGND VPWR VGND sky130_fd_sc_hd__decap_3
XPHY_EDGE_ROW_24_Left_52 VPWR VGND VPWR VGND sky130_fd_sc_hd__decap_3
XFILLER_18_21 VPWR VGND VPWR VGND sky130_fd_sc_hd__decap_3
XFILLER_18_32 VPWR VGND VPWR VGND sky130_fd_sc_hd__decap_3
XFILLER_18_65 VPWR VGND VPWR VGND sky130_fd_sc_hd__decap_3
XFILLER_20_44 VPWR VGND VPWR VGND sky130_fd_sc_hd__decap_3
XFILLER_20_77 VPWR VGND VPWR VGND sky130_fd_sc_hd__decap_3
XFILLER_20_88 VPWR VGND VPWR VGND sky130_fd_sc_hd__decap_3
XFILLER_6_24 VPWR VGND VPWR VGND sky130_fd_sc_hd__decap_3
XFILLER_6_35 VPWR VGND VPWR VGND sky130_fd_sc_hd__decap_3
XFILLER_6_68 VPWR VGND VPWR VGND sky130_fd_sc_hd__decap_3
XFILLER_19_140 VPWR VGND VPWR VGND sky130_fd_sc_hd__decap_3
XFILLER_19_184 VPWR VGND VPWR VGND sky130_fd_sc_hd__decap_3
XPHY_EDGE_ROW_6_Right_6 VPWR VGND VPWR VGND sky130_fd_sc_hd__decap_3
XFILLER_25_187 VPWR VGND VPWR VGND sky130_fd_sc_hd__decap_3
XFILLER_25_143 VPWR VGND VPWR VGND sky130_fd_sc_hd__decap_3
XFILLER_15_33 VPWR VGND VPWR VGND sky130_fd_sc_hd__decap_3
XFILLER_15_66 VPWR VGND VPWR VGND sky130_fd_sc_hd__decap_3
XFILLER_15_99 VPWR VGND VPWR VGND sky130_fd_sc_hd__decap_3
XFILLER_16_121 VPWR VGND VPWR VGND sky130_fd_sc_hd__decap_3
XFILLER_16_165 VPWR VGND VPWR VGND sky130_fd_sc_hd__decap_3
XFILLER_22_124 VPWR VGND VPWR VGND sky130_fd_sc_hd__decap_3
XFILLER_22_168 VPWR VGND VPWR VGND sky130_fd_sc_hd__decap_3
XFILLER_7_9 VPWR VGND VPWR VGND sky130_fd_sc_hd__decap_3
XFILLER_26_32 VPWR VGND VPWR VGND sky130_fd_sc_hd__decap_3
XFILLER_26_21 VPWR VGND VPWR VGND sky130_fd_sc_hd__decap_3
XFILLER_26_65 VPWR VGND VPWR VGND sky130_fd_sc_hd__decap_3
XFILLER_9_128 VPWR VGND VPWR VGND sky130_fd_sc_hd__decap_3
XFILLER_13_102 VPWR VGND VPWR VGND sky130_fd_sc_hd__decap_3
XFILLER_13_113 VPWR VGND VPWR VGND sky130_fd_sc_hd__decap_3
XFILLER_13_146 VPWR VGND VPWR VGND sky130_fd_sc_hd__decap_3
XFILLER_3_69 VPWR VGND VPWR VGND sky130_fd_sc_hd__decap_3
XFILLER_3_36 VPWR VGND VPWR VGND sky130_fd_sc_hd__decap_3
XFILLER_8_150 VPWR VGND VPWR VGND sky130_fd_sc_hd__decap_3
XFILLER_8_183 VPWR VGND VPWR VGND sky130_fd_sc_hd__decap_3
XFILLER_6_109 VPWR VGND VPWR VGND sky130_fd_sc_hd__decap_3
XFILLER_10_127 VPWR VGND VPWR VGND sky130_fd_sc_hd__decap_3
XFILLER_12_12 VPWR VGND VPWR VGND sky130_fd_sc_hd__decap_3
XFILLER_12_56 VPWR VGND VPWR VGND sky130_fd_sc_hd__decap_3
XFILLER_5_6 VPWR VGND VPWR VGND sky130_fd_sc_hd__decap_3
XFILLER_5_131 VPWR VGND VPWR VGND sky130_fd_sc_hd__decap_3
XFILLER_5_164 VPWR VGND VPWR VGND sky130_fd_sc_hd__decap_3
XFILLER_5_175 VPWR VGND VPWR VGND sky130_fd_sc_hd__decap_3
XFILLER_23_66 VPWR VGND VPWR VGND sky130_fd_sc_hd__decap_3
XFILLER_23_33 VPWR VGND VPWR VGND sky130_fd_sc_hd__decap_3
XFILLER_23_99 VPWR VGND VPWR VGND sky130_fd_sc_hd__decap_3
XFILLER_3_3 VPWR VGND VPWR VGND sky130_fd_sc_hd__decap_3
XFILLER_2_156 VPWR VGND VPWR VGND sky130_fd_sc_hd__decap_3
XFILLER_2_134 VPWR VGND VPWR VGND sky130_fd_sc_hd__decap_3
XFILLER_2_101 VPWR VGND VPWR VGND sky130_fd_sc_hd__decap_3
XFILLER_0_15 VPWR VGND VPWR VGND sky130_fd_sc_hd__decap_3
XFILLER_9_24 VPWR VGND VPWR VGND sky130_fd_sc_hd__decap_3
XFILLER_9_57 VPWR VGND VPWR VGND sky130_fd_sc_hd__decap_3
XFILLER_18_44 VPWR VGND VPWR VGND sky130_fd_sc_hd__decap_3
XFILLER_18_77 VPWR VGND VPWR VGND sky130_fd_sc_hd__decap_3
XFILLER_18_88 VPWR VGND VPWR VGND sky130_fd_sc_hd__decap_3
XFILLER_22_9 VPWR VGND VPWR VGND sky130_fd_sc_hd__decap_3
XFILLER_20_12 VPWR VGND VPWR VGND sky130_fd_sc_hd__decap_3
XFILLER_20_56 VPWR VGND VPWR VGND sky130_fd_sc_hd__decap_3
XFILLER_6_47 VPWR VGND VPWR VGND sky130_fd_sc_hd__decap_3
XFILLER_20_6 VPWR VGND VPWR VGND sky130_fd_sc_hd__decap_3
XFILLER_19_152 VPWR VGND VPWR VGND sky130_fd_sc_hd__decap_3
XFILLER_25_155 VPWR VGND VPWR VGND sky130_fd_sc_hd__decap_3
XFILLER_25_122 VPWR VGND VPWR VGND sky130_fd_sc_hd__decap_3
XFILLER_15_12 VPWR VGND VPWR VGND sky130_fd_sc_hd__decap_3
XFILLER_15_45 VPWR VGND VPWR VGND sky130_fd_sc_hd__decap_3
XFILLER_15_78 VPWR VGND VPWR VGND sky130_fd_sc_hd__decap_3
XFILLER_16_100 VPWR VGND VPWR VGND sky130_fd_sc_hd__decap_3
XFILLER_16_133 VPWR VGND VPWR VGND sky130_fd_sc_hd__decap_3
XFILLER_16_144 VPWR VGND VPWR VGND sky130_fd_sc_hd__decap_3
XFILLER_16_177 VPWR VGND VPWR VGND sky130_fd_sc_hd__decap_3
XFILLER_22_147 VPWR VGND VPWR VGND sky130_fd_sc_hd__decap_3
XFILLER_22_136 VPWR VGND VPWR VGND sky130_fd_sc_hd__decap_3
XFILLER_22_103 VPWR VGND VPWR VGND sky130_fd_sc_hd__decap_3
XFILLER_7_90 VPWR VGND VPWR VGND sky130_fd_sc_hd__decap_3
XFILLER_26_44 VPWR VGND VPWR VGND sky130_fd_sc_hd__decap_3
XFILLER_26_88 VPWR VGND VPWR VGND sky130_fd_sc_hd__decap_3
XFILLER_26_77 VPWR VGND VPWR VGND sky130_fd_sc_hd__decap_3
XFILLER_13_125 VPWR VGND VPWR VGND sky130_fd_sc_hd__decap_3
XFILLER_13_158 VPWR VGND VPWR VGND sky130_fd_sc_hd__decap_3
XFILLER_13_169 VPWR VGND VPWR VGND sky130_fd_sc_hd__decap_3
XFILLER_3_48 VPWR VGND VPWR VGND sky130_fd_sc_hd__decap_3
XFILLER_3_15 VPWR VGND VPWR VGND sky130_fd_sc_hd__decap_3
XFILLER_8_162 VPWR VGND VPWR VGND sky130_fd_sc_hd__decap_3
XFILLER_12_180 VPWR VGND VPWR VGND sky130_fd_sc_hd__decap_3
XFILLER_10_106 VPWR VGND VPWR VGND sky130_fd_sc_hd__decap_3
XFILLER_12_24 VPWR VGND VPWR VGND sky130_fd_sc_hd__decap_3
XFILLER_12_35 VPWR VGND VPWR VGND sky130_fd_sc_hd__decap_3
XFILLER_12_68 VPWR VGND VPWR VGND sky130_fd_sc_hd__decap_3
XFILLER_5_143 VPWR VGND VPWR VGND sky130_fd_sc_hd__decap_3
XFILLER_5_187 VPWR VGND VPWR VGND sky130_fd_sc_hd__decap_3
XFILLER_4_91 VPWR VGND VPWR VGND sky130_fd_sc_hd__decap_3
XFILLER_4_80 VPWR VGND VPWR VGND sky130_fd_sc_hd__decap_3
XFILLER_23_78 VPWR VGND VPWR VGND sky130_fd_sc_hd__decap_3
XFILLER_23_45 VPWR VGND VPWR VGND sky130_fd_sc_hd__decap_3
XFILLER_23_12 VPWR VGND VPWR VGND sky130_fd_sc_hd__decap_3
XFILLER_2_168 VPWR VGND VPWR VGND sky130_fd_sc_hd__decap_3
XFILLER_2_113 VPWR VGND VPWR VGND sky130_fd_sc_hd__decap_3
XFILLER_0_38 VPWR VGND VPWR VGND sky130_fd_sc_hd__decap_3
XFILLER_9_36 VPWR VGND VPWR VGND sky130_fd_sc_hd__decap_3
XFILLER_9_69 VPWR VGND VPWR VGND sky130_fd_sc_hd__decap_3
XFILLER_18_12 VPWR VGND VPWR VGND sky130_fd_sc_hd__decap_3
XFILLER_18_56 VPWR VGND VPWR VGND sky130_fd_sc_hd__decap_3
XFILLER_15_9 VPWR VGND VPWR VGND sky130_fd_sc_hd__decap_3
XFILLER_1_81 VPWR VGND VPWR VGND sky130_fd_sc_hd__decap_3
XFILLER_20_24 VPWR VGND VPWR VGND sky130_fd_sc_hd__decap_3
XFILLER_20_35 VPWR VGND VPWR VGND sky130_fd_sc_hd__decap_3
XFILLER_20_68 VPWR VGND VPWR VGND sky130_fd_sc_hd__decap_3
XFILLER_6_15 VPWR VGND VPWR VGND sky130_fd_sc_hd__decap_3
XFILLER_6_59 VPWR VGND VPWR VGND sky130_fd_sc_hd__decap_3
XFILLER_13_6 VPWR VGND VPWR VGND sky130_fd_sc_hd__decap_3
XFILLER_19_131 VPWR VGND VPWR VGND sky130_fd_sc_hd__decap_3
XFILLER_19_164 VPWR VGND VPWR VGND sky130_fd_sc_hd__decap_3
XFILLER_19_175 VPWR VGND VPWR VGND sky130_fd_sc_hd__decap_3
XFILLER_25_178 VPWR VGND VPWR VGND sky130_fd_sc_hd__decap_3
XFILLER_25_134 VPWR VGND VPWR VGND sky130_fd_sc_hd__decap_3
XFILLER_15_24 VPWR VGND VPWR VGND sky130_fd_sc_hd__decap_3
XFILLER_15_57 VPWR VGND VPWR VGND sky130_fd_sc_hd__decap_3
XFILLER_16_112 VPWR VGND VPWR VGND sky130_fd_sc_hd__decap_3
XFILLER_16_156 VPWR VGND VPWR VGND sky130_fd_sc_hd__decap_3
XFILLER_11_3 VPWR VGND VPWR VGND sky130_fd_sc_hd__decap_3
XFILLER_22_159 VPWR VGND VPWR VGND sky130_fd_sc_hd__decap_3
XFILLER_22_115 VPWR VGND VPWR VGND sky130_fd_sc_hd__decap_3
XFILLER_26_56 VPWR VGND VPWR VGND sky130_fd_sc_hd__decap_3
XFILLER_26_12 VPWR VGND VPWR VGND sky130_fd_sc_hd__decap_3
XFILLER_9_108 VPWR VGND VPWR VGND sky130_fd_sc_hd__decap_3
XFILLER_9_119 VPWR VGND VPWR VGND sky130_fd_sc_hd__decap_3
XFILLER_13_137 VPWR VGND VPWR VGND sky130_fd_sc_hd__decap_3
XFILLER_21_181 VPWR VGND VPWR VGND sky130_fd_sc_hd__decap_3
XFILLER_3_27 VPWR VGND VPWR VGND sky130_fd_sc_hd__decap_3
XFILLER_8_130 VPWR VGND VPWR VGND sky130_fd_sc_hd__decap_3
XFILLER_8_141 VPWR VGND VPWR VGND sky130_fd_sc_hd__decap_3
XFILLER_8_174 VPWR VGND VPWR VGND sky130_fd_sc_hd__decap_3
XFILLER_10_118 VPWR VGND VPWR VGND sky130_fd_sc_hd__decap_3
XFILLER_12_47 VPWR VGND VPWR VGND sky130_fd_sc_hd__decap_3
XFILLER_5_122 VPWR VGND VPWR VGND sky130_fd_sc_hd__decap_3
XFILLER_5_155 VPWR VGND VPWR VGND sky130_fd_sc_hd__decap_3
XFILLER_23_57 VPWR VGND VPWR VGND sky130_fd_sc_hd__decap_3
XFILLER_23_24 VPWR VGND VPWR VGND sky130_fd_sc_hd__decap_3
XFILLER_2_147 VPWR VGND VPWR VGND sky130_fd_sc_hd__decap_3
XFILLER_2_125 VPWR VGND VPWR VGND sky130_fd_sc_hd__decap_3
XFILLER_9_15 VPWR VGND VPWR VGND sky130_fd_sc_hd__decap_3
XFILLER_9_48 VPWR VGND VPWR VGND sky130_fd_sc_hd__decap_3
XFILLER_13_90 VPWR VGND VPWR VGND sky130_fd_sc_hd__decap_3
XFILLER_18_24 VPWR VGND VPWR VGND sky130_fd_sc_hd__decap_3
XFILLER_18_35 VPWR VGND VPWR VGND sky130_fd_sc_hd__decap_3
XFILLER_18_68 VPWR VGND VPWR VGND sky130_fd_sc_hd__decap_3
XFILLER_1_60 VPWR VGND VPWR VGND sky130_fd_sc_hd__decap_3
XFILLER_20_47 VPWR VGND VPWR VGND sky130_fd_sc_hd__decap_3
XFILLER_6_38 VPWR VGND VPWR VGND sky130_fd_sc_hd__decap_3
XFILLER_10_80 VPWR VGND VPWR VGND sky130_fd_sc_hd__decap_3
XFILLER_10_91 VPWR VGND VPWR VGND sky130_fd_sc_hd__decap_3
XFILLER_19_143 VPWR VGND VPWR VGND sky130_fd_sc_hd__decap_3
XFILLER_19_187 VPWR VGND VPWR VGND sky130_fd_sc_hd__decap_3
XFILLER_25_146 VPWR VGND VPWR VGND sky130_fd_sc_hd__decap_3
XFILLER_25_113 VPWR VGND VPWR VGND sky130_fd_sc_hd__decap_3
XFILLER_25_102 VPWR VGND VPWR VGND sky130_fd_sc_hd__decap_3
XFILLER_15_36 VPWR VGND VPWR VGND sky130_fd_sc_hd__decap_3
XFILLER_15_69 VPWR VGND VPWR VGND sky130_fd_sc_hd__decap_3
XFILLER_16_124 VPWR VGND VPWR VGND sky130_fd_sc_hd__decap_3
XFILLER_16_168 VPWR VGND VPWR VGND sky130_fd_sc_hd__decap_3
XPHY_EDGE_ROW_19_Right_19 VPWR VGND VPWR VGND sky130_fd_sc_hd__decap_3
XFILLER_21_90 VPWR VGND VPWR VGND sky130_fd_sc_hd__decap_3
XFILLER_22_127 VPWR VGND VPWR VGND sky130_fd_sc_hd__decap_3
XFILLER_7_81 VPWR VGND VPWR VGND sky130_fd_sc_hd__decap_3
XPHY_EDGE_ROW_15_Left_43 VPWR VGND VPWR VGND sky130_fd_sc_hd__decap_3
XFILLER_26_68 VPWR VGND VPWR VGND sky130_fd_sc_hd__decap_3
XFILLER_26_35 VPWR VGND VPWR VGND sky130_fd_sc_hd__decap_3
XFILLER_26_24 VPWR VGND VPWR VGND sky130_fd_sc_hd__decap_3
XFILLER_13_105 VPWR VGND VPWR VGND sky130_fd_sc_hd__decap_3
XFILLER_13_116 VPWR VGND VPWR VGND sky130_fd_sc_hd__decap_3
XFILLER_13_149 VPWR VGND VPWR VGND sky130_fd_sc_hd__decap_3
XFILLER_3_39 VPWR VGND VPWR VGND sky130_fd_sc_hd__decap_3
XFILLER_12_171 VPWR VGND VPWR VGND sky130_fd_sc_hd__decap_3
XFILLER_8_153 VPWR VGND VPWR VGND sky130_fd_sc_hd__decap_3
XFILLER_8_186 VPWR VGND VPWR VGND sky130_fd_sc_hd__decap_3
XFILLER_12_15 VPWR VGND VPWR VGND sky130_fd_sc_hd__decap_3
XFILLER_12_59 VPWR VGND VPWR VGND sky130_fd_sc_hd__decap_3
XFILLER_5_9 VPWR VGND VPWR VGND sky130_fd_sc_hd__decap_3
XPHY_EDGE_ROW_0_Left_28 VPWR VGND VPWR VGND sky130_fd_sc_hd__decap_3
XFILLER_5_134 VPWR VGND VPWR VGND sky130_fd_sc_hd__decap_3
XFILLER_5_178 VPWR VGND VPWR VGND sky130_fd_sc_hd__decap_3
XFILLER_4_71 VPWR VGND VPWR VGND sky130_fd_sc_hd__decap_3
XFILLER_23_36 VPWR VGND VPWR VGND sky130_fd_sc_hd__decap_3
XFILLER_23_69 VPWR VGND VPWR VGND sky130_fd_sc_hd__decap_3
XFILLER_2_104 VPWR VGND VPWR VGND sky130_fd_sc_hd__decap_3
XFILLER_3_6 VPWR VGND VPWR VGND sky130_fd_sc_hd__decap_3
XFILLER_2_159 VPWR VGND VPWR VGND sky130_fd_sc_hd__decap_3
XFILLER_2_137 VPWR VGND VPWR VGND sky130_fd_sc_hd__decap_3
XFILLER_0_18 VPWR VGND VPWR VGND sky130_fd_sc_hd__decap_3
XFILLER_0_29 VPWR VGND VPWR VGND sky130_fd_sc_hd__decap_3
XFILLER_9_27 VPWR VGND VPWR VGND sky130_fd_sc_hd__decap_3
XFILLER_1_181 VPWR VGND VPWR VGND sky130_fd_sc_hd__decap_3
XFILLER_18_47 VPWR VGND VPWR VGND sky130_fd_sc_hd__decap_3
XFILLER_1_3 VPWR VGND VPWR VGND sky130_fd_sc_hd__decap_3
XPHY_EDGE_ROW_3_Left_31 VPWR VGND VPWR VGND sky130_fd_sc_hd__decap_3
XFILLER_1_72 VPWR VGND VPWR VGND sky130_fd_sc_hd__decap_3
XFILLER_20_15 VPWR VGND VPWR VGND sky130_fd_sc_hd__decap_3
XFILLER_20_59 VPWR VGND VPWR VGND sky130_fd_sc_hd__decap_3
XFILLER_20_9 VPWR VGND VPWR VGND sky130_fd_sc_hd__decap_3
XFILLER_19_90 VPWR VGND VPWR VGND sky130_fd_sc_hd__decap_3
XFILLER_19_122 VPWR VGND VPWR VGND sky130_fd_sc_hd__decap_3
XFILLER_19_155 VPWR VGND VPWR VGND sky130_fd_sc_hd__decap_3
XFILLER_25_169 VPWR VGND VPWR VGND sky130_fd_sc_hd__decap_3
XFILLER_25_158 VPWR VGND VPWR VGND sky130_fd_sc_hd__decap_3
XFILLER_25_125 VPWR VGND VPWR VGND sky130_fd_sc_hd__decap_3
XFILLER_15_15 VPWR VGND VPWR VGND sky130_fd_sc_hd__decap_3
XFILLER_15_48 VPWR VGND VPWR VGND sky130_fd_sc_hd__decap_3
XFILLER_16_103 VPWR VGND VPWR VGND sky130_fd_sc_hd__decap_3
XFILLER_24_180 VPWR VGND VPWR VGND sky130_fd_sc_hd__decap_3
XFILLER_16_136 VPWR VGND VPWR VGND sky130_fd_sc_hd__decap_3
XFILLER_16_147 VPWR VGND VPWR VGND sky130_fd_sc_hd__decap_3
XFILLER_22_106 VPWR VGND VPWR VGND sky130_fd_sc_hd__decap_3
XFILLER_7_60 VPWR VGND VPWR VGND sky130_fd_sc_hd__decap_3
XFILLER_7_93 VPWR VGND VPWR VGND sky130_fd_sc_hd__decap_3
XFILLER_26_47 VPWR VGND VPWR VGND sky130_fd_sc_hd__decap_3
XFILLER_13_128 VPWR VGND VPWR VGND sky130_fd_sc_hd__decap_3
XFILLER_21_161 VPWR VGND VPWR VGND sky130_fd_sc_hd__decap_3
XFILLER_21_172 VPWR VGND VPWR VGND sky130_fd_sc_hd__decap_3
XFILLER_3_18 VPWR VGND VPWR VGND sky130_fd_sc_hd__decap_3
XFILLER_8_121 VPWR VGND VPWR VGND sky130_fd_sc_hd__decap_3
XFILLER_12_150 VPWR VGND VPWR VGND sky130_fd_sc_hd__decap_3
XFILLER_12_183 VPWR VGND VPWR VGND sky130_fd_sc_hd__decap_3
XFILLER_16_80 VPWR VGND VPWR VGND sky130_fd_sc_hd__decap_3
XFILLER_16_91 VPWR VGND VPWR VGND sky130_fd_sc_hd__decap_3
XFILLER_8_165 VPWR VGND VPWR VGND sky130_fd_sc_hd__decap_3
XFILLER_10_109 VPWR VGND VPWR VGND sky130_fd_sc_hd__decap_3
XFILLER_12_38 VPWR VGND VPWR VGND sky130_fd_sc_hd__decap_3
XFILLER_5_113 VPWR VGND VPWR VGND sky130_fd_sc_hd__decap_3
XFILLER_5_102 VPWR VGND VPWR VGND sky130_fd_sc_hd__decap_3
XFILLER_5_146 VPWR VGND VPWR VGND sky130_fd_sc_hd__decap_3
XFILLER_4_94 VPWR VGND VPWR VGND sky130_fd_sc_hd__decap_3
XFILLER_4_50 VPWR VGND VPWR VGND sky130_fd_sc_hd__decap_3
XFILLER_23_48 VPWR VGND VPWR VGND sky130_fd_sc_hd__decap_3
XFILLER_23_15 VPWR VGND VPWR VGND sky130_fd_sc_hd__decap_3
XFILLER_2_116 VPWR VGND VPWR VGND sky130_fd_sc_hd__decap_3
XFILLER_9_39 VPWR VGND VPWR VGND sky130_fd_sc_hd__decap_3
XFILLER_13_81 VPWR VGND VPWR VGND sky130_fd_sc_hd__decap_3
XFILLER_18_15 VPWR VGND VPWR VGND sky130_fd_sc_hd__decap_3
XFILLER_18_59 VPWR VGND VPWR VGND sky130_fd_sc_hd__decap_3
XFILLER_24_91 VPWR VGND VPWR VGND sky130_fd_sc_hd__decap_3
XFILLER_24_80 VPWR VGND VPWR VGND sky130_fd_sc_hd__decap_3
XFILLER_27_3 VPWR VGND VPWR VGND sky130_fd_sc_hd__decap_3
XFILLER_1_51 VPWR VGND VPWR VGND sky130_fd_sc_hd__decap_3
XFILLER_1_84 VPWR VGND VPWR VGND sky130_fd_sc_hd__decap_3
XFILLER_20_38 VPWR VGND VPWR VGND sky130_fd_sc_hd__decap_3
XFILLER_6_18 VPWR VGND VPWR VGND sky130_fd_sc_hd__decap_3
XFILLER_6_29 VPWR VGND VPWR VGND sky130_fd_sc_hd__decap_3
XFILLER_10_71 VPWR VGND VPWR VGND sky130_fd_sc_hd__decap_3
XFILLER_13_9 VPWR VGND VPWR VGND sky130_fd_sc_hd__decap_3
XFILLER_19_134 VPWR VGND VPWR VGND sky130_fd_sc_hd__decap_3
XFILLER_19_178 VPWR VGND VPWR VGND sky130_fd_sc_hd__decap_3
XFILLER_25_137 VPWR VGND VPWR VGND sky130_fd_sc_hd__decap_3
XFILLER_15_27 VPWR VGND VPWR VGND sky130_fd_sc_hd__decap_3
XPHY_EDGE_ROW_1_Right_1 VPWR VGND VPWR VGND sky130_fd_sc_hd__decap_3
XFILLER_16_115 VPWR VGND VPWR VGND sky130_fd_sc_hd__decap_3
XFILLER_16_159 VPWR VGND VPWR VGND sky130_fd_sc_hd__decap_3
XFILLER_21_81 VPWR VGND VPWR VGND sky130_fd_sc_hd__decap_3
XFILLER_11_6 VPWR VGND VPWR VGND sky130_fd_sc_hd__decap_3
XFILLER_22_118 VPWR VGND VPWR VGND sky130_fd_sc_hd__decap_3
XFILLER_7_72 VPWR VGND VPWR VGND sky130_fd_sc_hd__decap_3
XFILLER_15_181 VPWR VGND VPWR VGND sky130_fd_sc_hd__decap_3
XFILLER_26_15 VPWR VGND VPWR VGND sky130_fd_sc_hd__decap_3
XFILLER_26_59 VPWR VGND VPWR VGND sky130_fd_sc_hd__decap_3
XFILLER_21_140 VPWR VGND VPWR VGND sky130_fd_sc_hd__decap_3
XFILLER_21_184 VPWR VGND VPWR VGND sky130_fd_sc_hd__decap_3
XFILLER_8_100 VPWR VGND VPWR VGND sky130_fd_sc_hd__decap_3
XFILLER_8_133 VPWR VGND VPWR VGND sky130_fd_sc_hd__decap_3
XFILLER_8_144 VPWR VGND VPWR VGND sky130_fd_sc_hd__decap_3
XFILLER_8_177 VPWR VGND VPWR VGND sky130_fd_sc_hd__decap_3
XFILLER_12_162 VPWR VGND VPWR VGND sky130_fd_sc_hd__decap_3
XFILLER_5_125 VPWR VGND VPWR VGND sky130_fd_sc_hd__decap_3
XFILLER_5_158 VPWR VGND VPWR VGND sky130_fd_sc_hd__decap_3
XFILLER_5_169 VPWR VGND VPWR VGND sky130_fd_sc_hd__decap_3
XFILLER_27_91 VPWR VGND VPWR VGND sky130_fd_sc_hd__decap_3
XFILLER_4_180 VPWR VGND VPWR VGND sky130_fd_sc_hd__decap_3
XFILLER_4_62 VPWR VGND VPWR VGND sky130_fd_sc_hd__decap_3
XFILLER_23_27 VPWR VGND VPWR VGND sky130_fd_sc_hd__decap_3
XFILLER_2_128 VPWR VGND VPWR VGND sky130_fd_sc_hd__decap_3
XFILLER_9_18 VPWR VGND VPWR VGND sky130_fd_sc_hd__decap_3
XFILLER_13_60 VPWR VGND VPWR VGND sky130_fd_sc_hd__decap_3
XFILLER_13_93 VPWR VGND VPWR VGND sky130_fd_sc_hd__decap_3
XFILLER_1_172 VPWR VGND VPWR VGND sky130_fd_sc_hd__decap_3
XFILLER_1_161 VPWR VGND VPWR VGND sky130_fd_sc_hd__decap_3
XFILLER_18_38 VPWR VGND VPWR VGND sky130_fd_sc_hd__decap_3
XFILLER_1_30 VPWR VGND VPWR VGND sky130_fd_sc_hd__decap_3
XFILLER_1_63 VPWR VGND VPWR VGND sky130_fd_sc_hd__decap_3
XFILLER_10_50 VPWR VGND VPWR VGND sky130_fd_sc_hd__decap_3
XFILLER_10_94 VPWR VGND VPWR VGND sky130_fd_sc_hd__decap_3
XFILLER_19_102 VPWR VGND VPWR VGND sky130_fd_sc_hd__decap_3
XFILLER_19_113 VPWR VGND VPWR VGND sky130_fd_sc_hd__decap_3
XFILLER_19_81 VPWR VGND VPWR VGND sky130_fd_sc_hd__decap_3
XFILLER_19_146 VPWR VGND VPWR VGND sky130_fd_sc_hd__decap_3
XFILLER_25_105 VPWR VGND VPWR VGND sky130_fd_sc_hd__decap_3
XFILLER_25_149 VPWR VGND VPWR VGND sky130_fd_sc_hd__decap_3
XFILLER_25_116 VPWR VGND VPWR VGND sky130_fd_sc_hd__decap_3
XFILLER_15_39 VPWR VGND VPWR VGND sky130_fd_sc_hd__decap_3
XFILLER_16_127 VPWR VGND VPWR VGND sky130_fd_sc_hd__decap_3
XFILLER_24_171 VPWR VGND VPWR VGND sky130_fd_sc_hd__decap_3
XFILLER_21_60 VPWR VGND VPWR VGND sky130_fd_sc_hd__decap_3
XFILLER_21_93 VPWR VGND VPWR VGND sky130_fd_sc_hd__decap_3
XFILLER_7_51 VPWR VGND VPWR VGND sky130_fd_sc_hd__decap_3
XFILLER_7_84 VPWR VGND VPWR VGND sky130_fd_sc_hd__decap_3
XPHY_EDGE_ROW_15_Right_15 VPWR VGND VPWR VGND sky130_fd_sc_hd__decap_3
XFILLER_26_38 VPWR VGND VPWR VGND sky130_fd_sc_hd__decap_3
XPHY_EDGE_ROW_24_Right_24 VPWR VGND VPWR VGND sky130_fd_sc_hd__decap_3
XFILLER_13_108 VPWR VGND VPWR VGND sky130_fd_sc_hd__decap_3
XFILLER_13_119 VPWR VGND VPWR VGND sky130_fd_sc_hd__decap_3
XFILLER_21_152 VPWR VGND VPWR VGND sky130_fd_sc_hd__decap_3
XFILLER_16_71 VPWR VGND VPWR VGND sky130_fd_sc_hd__decap_3
XFILLER_8_112 VPWR VGND VPWR VGND sky130_fd_sc_hd__decap_3
XFILLER_8_156 VPWR VGND VPWR VGND sky130_fd_sc_hd__decap_3
XFILLER_12_130 VPWR VGND VPWR VGND sky130_fd_sc_hd__decap_3
XFILLER_12_141 VPWR VGND VPWR VGND sky130_fd_sc_hd__decap_3
XFILLER_12_174 VPWR VGND VPWR VGND sky130_fd_sc_hd__decap_3
XPHY_EDGE_ROW_19_Left_47 VPWR VGND VPWR VGND sky130_fd_sc_hd__decap_3
XFILLER_12_18 VPWR VGND VPWR VGND sky130_fd_sc_hd__decap_3
XFILLER_12_29 VPWR VGND VPWR VGND sky130_fd_sc_hd__decap_3
XFILLER_5_137 VPWR VGND VPWR VGND sky130_fd_sc_hd__decap_3
XFILLER_27_81 VPWR VGND VPWR VGND sky130_fd_sc_hd__decap_3
XFILLER_4_85 VPWR VGND VPWR VGND sky130_fd_sc_hd__decap_3
XFILLER_4_74 VPWR VGND VPWR VGND sky130_fd_sc_hd__decap_3
XFILLER_4_41 VPWR VGND VPWR VGND sky130_fd_sc_hd__decap_3
XFILLER_23_39 VPWR VGND VPWR VGND sky130_fd_sc_hd__decap_3
XFILLER_3_9 VPWR VGND VPWR VGND sky130_fd_sc_hd__decap_3
XFILLER_2_107 VPWR VGND VPWR VGND sky130_fd_sc_hd__decap_3
XFILLER_13_72 VPWR VGND VPWR VGND sky130_fd_sc_hd__decap_3
XFILLER_1_184 VPWR VGND VPWR VGND sky130_fd_sc_hd__decap_3
XFILLER_1_140 VPWR VGND VPWR VGND sky130_fd_sc_hd__decap_3
XFILLER_1_6 VPWR VGND VPWR VGND sky130_fd_sc_hd__decap_3
XFILLER_24_71 VPWR VGND VPWR VGND sky130_fd_sc_hd__decap_3
XFILLER_1_42 VPWR VGND VPWR VGND sky130_fd_sc_hd__decap_3
XFILLER_1_75 VPWR VGND VPWR VGND sky130_fd_sc_hd__decap_3
XFILLER_20_18 VPWR VGND VPWR VGND sky130_fd_sc_hd__decap_3
XFILLER_20_29 VPWR VGND VPWR VGND sky130_fd_sc_hd__decap_3
XPHY_EDGE_ROW_7_Left_35 VPWR VGND VPWR VGND sky130_fd_sc_hd__decap_3
XFILLER_10_62 VPWR VGND VPWR VGND sky130_fd_sc_hd__decap_3
XFILLER_19_60 VPWR VGND VPWR VGND sky130_fd_sc_hd__decap_3
XFILLER_19_125 VPWR VGND VPWR VGND sky130_fd_sc_hd__decap_3
XFILLER_19_93 VPWR VGND VPWR VGND sky130_fd_sc_hd__decap_3
XFILLER_19_158 VPWR VGND VPWR VGND sky130_fd_sc_hd__decap_3
XFILLER_19_169 VPWR VGND VPWR VGND sky130_fd_sc_hd__decap_3
XFILLER_25_128 VPWR VGND VPWR VGND sky130_fd_sc_hd__decap_3
XFILLER_15_18 VPWR VGND VPWR VGND sky130_fd_sc_hd__decap_3
XFILLER_18_180 VPWR VGND VPWR VGND sky130_fd_sc_hd__decap_3
XFILLER_24_150 VPWR VGND VPWR VGND sky130_fd_sc_hd__decap_3
XFILLER_16_106 VPWR VGND VPWR VGND sky130_fd_sc_hd__decap_3
XFILLER_24_183 VPWR VGND VPWR VGND sky130_fd_sc_hd__decap_3
XFILLER_21_72 VPWR VGND VPWR VGND sky130_fd_sc_hd__decap_3
XFILLER_22_109 VPWR VGND VPWR VGND sky130_fd_sc_hd__decap_3
XFILLER_15_161 VPWR VGND VPWR VGND sky130_fd_sc_hd__decap_3
XFILLER_15_172 VPWR VGND VPWR VGND sky130_fd_sc_hd__decap_3
XFILLER_7_30 VPWR VGND VPWR VGND sky130_fd_sc_hd__decap_3
XFILLER_7_63 VPWR VGND VPWR VGND sky130_fd_sc_hd__decap_3
XFILLER_7_96 VPWR VGND VPWR VGND sky130_fd_sc_hd__decap_3
XFILLER_21_131 VPWR VGND VPWR VGND sky130_fd_sc_hd__decap_3
XFILLER_21_164 VPWR VGND VPWR VGND sky130_fd_sc_hd__decap_3
XFILLER_21_175 VPWR VGND VPWR VGND sky130_fd_sc_hd__decap_3
XFILLER_12_153 VPWR VGND VPWR VGND sky130_fd_sc_hd__decap_3
XFILLER_16_50 VPWR VGND VPWR VGND sky130_fd_sc_hd__decap_3
XFILLER_16_94 VPWR VGND VPWR VGND sky130_fd_sc_hd__decap_3
XFILLER_8_124 VPWR VGND VPWR VGND sky130_fd_sc_hd__decap_3
XFILLER_8_168 VPWR VGND VPWR VGND sky130_fd_sc_hd__decap_3
XFILLER_12_186 VPWR VGND VPWR VGND sky130_fd_sc_hd__decap_3
XFILLER_5_116 VPWR VGND VPWR VGND sky130_fd_sc_hd__decap_3
XFILLER_5_105 VPWR VGND VPWR VGND sky130_fd_sc_hd__decap_3
XFILLER_5_149 VPWR VGND VPWR VGND sky130_fd_sc_hd__decap_3
XFILLER_27_60 VPWR VGND VPWR VGND sky130_fd_sc_hd__decap_3
XPHY_EDGE_ROW_20_Left_48 VPWR VGND VPWR VGND sky130_fd_sc_hd__decap_3
XFILLER_4_171 VPWR VGND VPWR VGND sky130_fd_sc_hd__decap_3
XFILLER_4_97 VPWR VGND VPWR VGND sky130_fd_sc_hd__decap_3
XFILLER_4_53 VPWR VGND VPWR VGND sky130_fd_sc_hd__decap_3
XFILLER_23_18 VPWR VGND VPWR VGND sky130_fd_sc_hd__decap_3
XFILLER_2_119 VPWR VGND VPWR VGND sky130_fd_sc_hd__decap_3
XFILLER_13_51 VPWR VGND VPWR VGND sky130_fd_sc_hd__decap_3
XFILLER_13_84 VPWR VGND VPWR VGND sky130_fd_sc_hd__decap_3
XFILLER_1_152 VPWR VGND VPWR VGND sky130_fd_sc_hd__decap_3
XFILLER_18_18 VPWR VGND VPWR VGND sky130_fd_sc_hd__decap_3
XFILLER_18_29 VPWR VGND VPWR VGND sky130_fd_sc_hd__decap_3
XFILLER_24_94 VPWR VGND VPWR VGND sky130_fd_sc_hd__decap_3
XFILLER_24_50 VPWR VGND VPWR VGND sky130_fd_sc_hd__decap_3
XFILLER_27_6 VPWR VGND VPWR VGND sky130_fd_sc_hd__decap_3
XFILLER_1_21 VPWR VGND VPWR VGND sky130_fd_sc_hd__decap_3
XPHY_EDGE_ROW_23_Left_51 VPWR VGND VPWR VGND sky130_fd_sc_hd__decap_3
XFILLER_10_41 VPWR VGND VPWR VGND sky130_fd_sc_hd__decap_3
XFILLER_10_74 VPWR VGND VPWR VGND sky130_fd_sc_hd__decap_3
XFILLER_10_85 VPWR VGND VPWR VGND sky130_fd_sc_hd__decap_3
XFILLER_19_72 VPWR VGND VPWR VGND sky130_fd_sc_hd__decap_3
XFILLER_19_137 VPWR VGND VPWR VGND sky130_fd_sc_hd__decap_3
XFILLER_27_181 VPWR VGND VPWR VGND sky130_fd_sc_hd__decap_3
XFILLER_25_3 VPWR VGND VPWR VGND sky130_fd_sc_hd__decap_3
XFILLER_24_162 VPWR VGND VPWR VGND sky130_fd_sc_hd__decap_3
XFILLER_16_118 VPWR VGND VPWR VGND sky130_fd_sc_hd__decap_3
XFILLER_21_51 VPWR VGND VPWR VGND sky130_fd_sc_hd__decap_3
XFILLER_21_84 VPWR VGND VPWR VGND sky130_fd_sc_hd__decap_3
XFILLER_11_9 VPWR VGND VPWR VGND sky130_fd_sc_hd__decap_3
XFILLER_15_140 VPWR VGND VPWR VGND sky130_fd_sc_hd__decap_3
XFILLER_15_184 VPWR VGND VPWR VGND sky130_fd_sc_hd__decap_3
XFILLER_7_42 VPWR VGND VPWR VGND sky130_fd_sc_hd__decap_3
XFILLER_7_75 VPWR VGND VPWR VGND sky130_fd_sc_hd__decap_3
XFILLER_26_29 VPWR VGND VPWR VGND sky130_fd_sc_hd__decap_3
XFILLER_26_18 VPWR VGND VPWR VGND sky130_fd_sc_hd__decap_3
XPHY_EDGE_ROW_5_Right_5 VPWR VGND VPWR VGND sky130_fd_sc_hd__decap_3
XFILLER_21_143 VPWR VGND VPWR VGND sky130_fd_sc_hd__decap_3
XFILLER_21_187 VPWR VGND VPWR VGND sky130_fd_sc_hd__decap_3
XFILLER_8_103 VPWR VGND VPWR VGND sky130_fd_sc_hd__decap_3
XFILLER_8_136 VPWR VGND VPWR VGND sky130_fd_sc_hd__decap_3
XFILLER_12_121 VPWR VGND VPWR VGND sky130_fd_sc_hd__decap_3
XFILLER_12_165 VPWR VGND VPWR VGND sky130_fd_sc_hd__decap_3
XFILLER_16_62 VPWR VGND VPWR VGND sky130_fd_sc_hd__decap_3
XFILLER_8_147 VPWR VGND VPWR VGND sky130_fd_sc_hd__decap_3
XFILLER_5_128 VPWR VGND VPWR VGND sky130_fd_sc_hd__decap_3
XFILLER_27_94 VPWR VGND VPWR VGND sky130_fd_sc_hd__decap_3
XFILLER_27_72 VPWR VGND VPWR VGND sky130_fd_sc_hd__decap_3
XFILLER_27_50 VPWR VGND VPWR VGND sky130_fd_sc_hd__decap_3
XFILLER_4_183 VPWR VGND VPWR VGND sky130_fd_sc_hd__decap_3
XFILLER_4_150 VPWR VGND VPWR VGND sky130_fd_sc_hd__decap_3
XFILLER_4_65 VPWR VGND VPWR VGND sky130_fd_sc_hd__decap_3
XFILLER_4_32 VPWR VGND VPWR VGND sky130_fd_sc_hd__decap_3
XFILLER_4_21 VPWR VGND VPWR VGND sky130_fd_sc_hd__decap_3
XFILLER_13_30 VPWR VGND VPWR VGND sky130_fd_sc_hd__decap_3
XFILLER_13_63 VPWR VGND VPWR VGND sky130_fd_sc_hd__decap_3
XFILLER_1_131 VPWR VGND VPWR VGND sky130_fd_sc_hd__decap_3
XFILLER_13_96 VPWR VGND VPWR VGND sky130_fd_sc_hd__decap_3
XFILLER_1_175 VPWR VGND VPWR VGND sky130_fd_sc_hd__decap_3
XFILLER_1_164 VPWR VGND VPWR VGND sky130_fd_sc_hd__decap_3
XFILLER_24_62 VPWR VGND VPWR VGND sky130_fd_sc_hd__decap_3
XFILLER_1_33 VPWR VGND VPWR VGND sky130_fd_sc_hd__decap_3
XFILLER_1_66 VPWR VGND VPWR VGND sky130_fd_sc_hd__decap_3
XFILLER_10_53 VPWR VGND VPWR VGND sky130_fd_sc_hd__decap_3
XFILLER_10_97 VPWR VGND VPWR VGND sky130_fd_sc_hd__decap_3
XFILLER_19_51 VPWR VGND VPWR VGND sky130_fd_sc_hd__decap_3
XFILLER_19_84 VPWR VGND VPWR VGND sky130_fd_sc_hd__decap_3
XFILLER_19_105 VPWR VGND VPWR VGND sky130_fd_sc_hd__decap_3
XFILLER_19_116 VPWR VGND VPWR VGND sky130_fd_sc_hd__decap_3
XFILLER_19_149 VPWR VGND VPWR VGND sky130_fd_sc_hd__decap_3
XFILLER_18_3 VPWR VGND VPWR VGND sky130_fd_sc_hd__decap_3
XFILLER_25_119 VPWR VGND VPWR VGND sky130_fd_sc_hd__decap_3
XFILLER_25_108 VPWR VGND VPWR VGND sky130_fd_sc_hd__decap_3
XFILLER_18_171 VPWR VGND VPWR VGND sky130_fd_sc_hd__decap_3
XFILLER_24_174 VPWR VGND VPWR VGND sky130_fd_sc_hd__decap_3
XFILLER_24_141 VPWR VGND VPWR VGND sky130_fd_sc_hd__decap_3
XFILLER_24_130 VPWR VGND VPWR VGND sky130_fd_sc_hd__decap_3
XFILLER_21_30 VPWR VGND VPWR VGND sky130_fd_sc_hd__decap_3
XFILLER_21_63 VPWR VGND VPWR VGND sky130_fd_sc_hd__decap_3
XFILLER_21_96 VPWR VGND VPWR VGND sky130_fd_sc_hd__decap_3
XFILLER_15_152 VPWR VGND VPWR VGND sky130_fd_sc_hd__decap_3
XFILLER_7_21 VPWR VGND VPWR VGND sky130_fd_sc_hd__decap_3
XFILLER_7_87 VPWR VGND VPWR VGND sky130_fd_sc_hd__decap_3
XFILLER_21_122 VPWR VGND VPWR VGND sky130_fd_sc_hd__decap_3
XFILLER_21_155 VPWR VGND VPWR VGND sky130_fd_sc_hd__decap_3
XFILLER_16_41 VPWR VGND VPWR VGND sky130_fd_sc_hd__decap_3
XFILLER_8_115 VPWR VGND VPWR VGND sky130_fd_sc_hd__decap_3
XFILLER_8_159 VPWR VGND VPWR VGND sky130_fd_sc_hd__decap_3
XPHY_EDGE_ROW_11_Right_11 VPWR VGND VPWR VGND sky130_fd_sc_hd__decap_3
XFILLER_12_100 VPWR VGND VPWR VGND sky130_fd_sc_hd__decap_3
XFILLER_12_133 VPWR VGND VPWR VGND sky130_fd_sc_hd__decap_3
XFILLER_12_144 VPWR VGND VPWR VGND sky130_fd_sc_hd__decap_3
XFILLER_12_177 VPWR VGND VPWR VGND sky130_fd_sc_hd__decap_3
XFILLER_16_74 VPWR VGND VPWR VGND sky130_fd_sc_hd__decap_3
XFILLER_16_85 VPWR VGND VPWR VGND sky130_fd_sc_hd__decap_3
XPHY_EDGE_ROW_20_Right_20 VPWR VGND VPWR VGND sky130_fd_sc_hd__decap_3
XFILLER_7_181 VPWR VGND VPWR VGND sky130_fd_sc_hd__decap_3
XFILLER_4_162 VPWR VGND VPWR VGND sky130_fd_sc_hd__decap_3
XFILLER_4_88 VPWR VGND VPWR VGND sky130_fd_sc_hd__decap_3
XFILLER_4_77 VPWR VGND VPWR VGND sky130_fd_sc_hd__decap_3
XFILLER_4_44 VPWR VGND VPWR VGND sky130_fd_sc_hd__decap_3
XFILLER_13_42 VPWR VGND VPWR VGND sky130_fd_sc_hd__decap_3
XFILLER_13_75 VPWR VGND VPWR VGND sky130_fd_sc_hd__decap_3
XFILLER_1_143 VPWR VGND VPWR VGND sky130_fd_sc_hd__decap_3
XFILLER_1_187 VPWR VGND VPWR VGND sky130_fd_sc_hd__decap_3
XFILLER_1_9 VPWR VGND VPWR VGND sky130_fd_sc_hd__decap_3
XFILLER_24_85 VPWR VGND VPWR VGND sky130_fd_sc_hd__decap_3
XFILLER_24_74 VPWR VGND VPWR VGND sky130_fd_sc_hd__decap_3
XFILLER_24_41 VPWR VGND VPWR VGND sky130_fd_sc_hd__decap_3
XFILLER_1_12 VPWR VGND VPWR VGND sky130_fd_sc_hd__decap_3
XFILLER_1_45 VPWR VGND VPWR VGND sky130_fd_sc_hd__decap_3
XFILLER_1_78 VPWR VGND VPWR VGND sky130_fd_sc_hd__decap_3
XFILLER_10_21 VPWR VGND VPWR VGND sky130_fd_sc_hd__decap_3
XFILLER_10_32 VPWR VGND VPWR VGND sky130_fd_sc_hd__decap_3
XFILLER_10_65 VPWR VGND VPWR VGND sky130_fd_sc_hd__decap_3
XFILLER_19_30 VPWR VGND VPWR VGND sky130_fd_sc_hd__decap_3
XFILLER_27_172 VPWR VGND VPWR VGND sky130_fd_sc_hd__decap_3
XFILLER_27_150 VPWR VGND VPWR VGND sky130_fd_sc_hd__decap_3
XFILLER_19_63 VPWR VGND VPWR VGND sky130_fd_sc_hd__decap_3
XFILLER_19_96 VPWR VGND VPWR VGND sky130_fd_sc_hd__decap_3
XFILLER_19_128 VPWR VGND VPWR VGND sky130_fd_sc_hd__decap_3
XFILLER_18_150 VPWR VGND VPWR VGND sky130_fd_sc_hd__decap_3
XFILLER_18_183 VPWR VGND VPWR VGND sky130_fd_sc_hd__decap_3
XFILLER_16_109 VPWR VGND VPWR VGND sky130_fd_sc_hd__decap_3
XFILLER_24_186 VPWR VGND VPWR VGND sky130_fd_sc_hd__decap_3
XFILLER_24_153 VPWR VGND VPWR VGND sky130_fd_sc_hd__decap_3
XFILLER_21_42 VPWR VGND VPWR VGND sky130_fd_sc_hd__decap_3
XFILLER_21_75 VPWR VGND VPWR VGND sky130_fd_sc_hd__decap_3
XFILLER_15_131 VPWR VGND VPWR VGND sky130_fd_sc_hd__decap_3
XFILLER_15_164 VPWR VGND VPWR VGND sky130_fd_sc_hd__decap_3
XFILLER_15_175 VPWR VGND VPWR VGND sky130_fd_sc_hd__decap_3
XFILLER_7_33 VPWR VGND VPWR VGND sky130_fd_sc_hd__decap_3
XFILLER_7_66 VPWR VGND VPWR VGND sky130_fd_sc_hd__decap_3
XFILLER_7_99 VPWR VGND VPWR VGND sky130_fd_sc_hd__decap_3
XFILLER_21_134 VPWR VGND VPWR VGND sky130_fd_sc_hd__decap_3
XFILLER_21_178 VPWR VGND VPWR VGND sky130_fd_sc_hd__decap_3
XFILLER_16_53 VPWR VGND VPWR VGND sky130_fd_sc_hd__decap_3
XFILLER_8_127 VPWR VGND VPWR VGND sky130_fd_sc_hd__decap_3
XFILLER_12_112 VPWR VGND VPWR VGND sky130_fd_sc_hd__decap_3
XFILLER_12_156 VPWR VGND VPWR VGND sky130_fd_sc_hd__decap_3
XFILLER_16_97 VPWR VGND VPWR VGND sky130_fd_sc_hd__decap_3
XFILLER_5_119 VPWR VGND VPWR VGND sky130_fd_sc_hd__decap_3
XFILLER_5_108 VPWR VGND VPWR VGND sky130_fd_sc_hd__decap_3
XFILLER_27_63 VPWR VGND VPWR VGND sky130_fd_sc_hd__decap_3
XFILLER_27_41 VPWR VGND VPWR VGND sky130_fd_sc_hd__decap_3
XFILLER_27_85 VPWR VGND VPWR VGND sky130_fd_sc_hd__decap_3
XFILLER_4_141 VPWR VGND VPWR VGND sky130_fd_sc_hd__decap_3
XFILLER_4_130 VPWR VGND VPWR VGND sky130_fd_sc_hd__decap_3
XFILLER_4_174 VPWR VGND VPWR VGND sky130_fd_sc_hd__decap_3
XFILLER_4_56 VPWR VGND VPWR VGND sky130_fd_sc_hd__decap_3
XFILLER_4_12 VPWR VGND VPWR VGND sky130_fd_sc_hd__decap_3
XFILLER_13_21 VPWR VGND VPWR VGND sky130_fd_sc_hd__decap_3
XFILLER_13_87 VPWR VGND VPWR VGND sky130_fd_sc_hd__decap_3
XFILLER_1_155 VPWR VGND VPWR VGND sky130_fd_sc_hd__decap_3
XFILLER_1_122 VPWR VGND VPWR VGND sky130_fd_sc_hd__decap_3
XFILLER_8_3 VPWR VGND VPWR VGND sky130_fd_sc_hd__decap_3
XFILLER_24_97 VPWR VGND VPWR VGND sky130_fd_sc_hd__decap_3
XFILLER_24_53 VPWR VGND VPWR VGND sky130_fd_sc_hd__decap_3
XFILLER_27_9 VPWR VGND VPWR VGND sky130_fd_sc_hd__decap_3
XFILLER_1_24 VPWR VGND VPWR VGND sky130_fd_sc_hd__decap_3
XFILLER_1_57 VPWR VGND VPWR VGND sky130_fd_sc_hd__decap_3
Xinput1 VGND VPWR VPWR VGND enable u_nand/A input1/a_244_47# input1/a_355_47# input1/a_27_47#
+ sky130_fd_sc_hd__clkdlybuf4s25_1
XFILLER_10_44 VPWR VGND VPWR VGND sky130_fd_sc_hd__decap_3
XFILLER_10_77 VPWR VGND VPWR VGND sky130_fd_sc_hd__decap_3
XFILLER_10_88 VPWR VGND VPWR VGND sky130_fd_sc_hd__decap_3
XFILLER_19_42 VPWR VGND VPWR VGND sky130_fd_sc_hd__decap_3
XFILLER_27_184 VPWR VGND VPWR VGND sky130_fd_sc_hd__decap_3
XFILLER_27_162 VPWR VGND VPWR VGND sky130_fd_sc_hd__decap_3
XFILLER_19_75 VPWR VGND VPWR VGND sky130_fd_sc_hd__decap_3
XPHY_EDGE_ROW_27_Left_55 VPWR VGND VPWR VGND sky130_fd_sc_hd__decap_3
XFILLER_25_6 VPWR VGND VPWR VGND sky130_fd_sc_hd__decap_3
XPHY_EDGE_ROW_11_Left_39 VPWR VGND VPWR VGND sky130_fd_sc_hd__decap_3
XFILLER_18_162 VPWR VGND VPWR VGND sky130_fd_sc_hd__decap_3
XFILLER_24_121 VPWR VGND VPWR VGND sky130_fd_sc_hd__decap_3
XFILLER_24_165 VPWR VGND VPWR VGND sky130_fd_sc_hd__decap_3
XFILLER_21_21 VPWR VGND VPWR VGND sky130_fd_sc_hd__decap_3
XFILLER_21_87 VPWR VGND VPWR VGND sky130_fd_sc_hd__decap_3
XFILLER_15_143 VPWR VGND VPWR VGND sky130_fd_sc_hd__decap_3
XFILLER_15_187 VPWR VGND VPWR VGND sky130_fd_sc_hd__decap_3
XFILLER_7_12 VPWR VGND VPWR VGND sky130_fd_sc_hd__decap_3
XFILLER_7_45 VPWR VGND VPWR VGND sky130_fd_sc_hd__decap_3
XFILLER_7_78 VPWR VGND VPWR VGND sky130_fd_sc_hd__decap_3
XFILLER_23_3 VPWR VGND VPWR VGND sky130_fd_sc_hd__decap_3
XFILLER_21_102 VPWR VGND VPWR VGND sky130_fd_sc_hd__decap_3
XFILLER_21_113 VPWR VGND VPWR VGND sky130_fd_sc_hd__decap_3
XFILLER_21_146 VPWR VGND VPWR VGND sky130_fd_sc_hd__decap_3
XFILLER_12_124 VPWR VGND VPWR VGND sky130_fd_sc_hd__decap_3
XFILLER_16_21 VPWR VGND VPWR VGND sky130_fd_sc_hd__decap_3
XFILLER_16_32 VPWR VGND VPWR VGND sky130_fd_sc_hd__decap_3
XFILLER_16_65 VPWR VGND VPWR VGND sky130_fd_sc_hd__decap_3
XFILLER_8_106 VPWR VGND VPWR VGND sky130_fd_sc_hd__decap_3
XFILLER_12_168 VPWR VGND VPWR VGND sky130_fd_sc_hd__decap_3
XFILLER_7_161 VPWR VGND VPWR VGND sky130_fd_sc_hd__decap_3
XFILLER_7_172 VPWR VGND VPWR VGND sky130_fd_sc_hd__decap_3
XPHY_EDGE_ROW_9_Right_9 VPWR VGND VPWR VGND sky130_fd_sc_hd__decap_3
XPHY_EDGE_ROW_14_Left_42 VPWR VGND VPWR VGND sky130_fd_sc_hd__decap_3
XFILLER_27_75 VPWR VGND VPWR VGND sky130_fd_sc_hd__decap_3
XFILLER_27_53 VPWR VGND VPWR VGND sky130_fd_sc_hd__decap_3
XFILLER_27_97 VPWR VGND VPWR VGND sky130_fd_sc_hd__decap_3
XFILLER_4_153 VPWR VGND VPWR VGND sky130_fd_sc_hd__decap_3
XFILLER_4_24 VPWR VGND VPWR VGND sky130_fd_sc_hd__decap_3
XFILLER_4_186 VPWR VGND VPWR VGND sky130_fd_sc_hd__decap_3
XFILLER_4_68 VPWR VGND VPWR VGND sky130_fd_sc_hd__decap_3
XFILLER_4_35 VPWR VGND VPWR VGND sky130_fd_sc_hd__decap_3
XFILLER_13_33 VPWR VGND VPWR VGND sky130_fd_sc_hd__decap_3
XFILLER_13_66 VPWR VGND VPWR VGND sky130_fd_sc_hd__decap_3
XFILLER_13_99 VPWR VGND VPWR VGND sky130_fd_sc_hd__decap_3
XFILLER_1_178 VPWR VGND VPWR VGND sky130_fd_sc_hd__decap_3
XFILLER_1_134 VPWR VGND VPWR VGND sky130_fd_sc_hd__decap_3
XFILLER_24_65 VPWR VGND VPWR VGND sky130_fd_sc_hd__decap_3
XFILLER_24_32 VPWR VGND VPWR VGND sky130_fd_sc_hd__decap_3
XFILLER_24_21 VPWR VGND VPWR VGND sky130_fd_sc_hd__decap_3
XFILLER_1_36 VPWR VGND VPWR VGND sky130_fd_sc_hd__decap_3
XFILLER_1_69 VPWR VGND VPWR VGND sky130_fd_sc_hd__decap_3
XFILLER_10_12 VPWR VGND VPWR VGND sky130_fd_sc_hd__decap_3
XFILLER_10_56 VPWR VGND VPWR VGND sky130_fd_sc_hd__decap_3
XFILLER_19_21 VPWR VGND VPWR VGND sky130_fd_sc_hd__decap_3
XFILLER_19_87 VPWR VGND VPWR VGND sky130_fd_sc_hd__decap_3
XFILLER_19_108 VPWR VGND VPWR VGND sky130_fd_sc_hd__decap_3
XFILLER_19_119 VPWR VGND VPWR VGND sky130_fd_sc_hd__decap_3
XFILLER_27_141 VPWR VGND VPWR VGND sky130_fd_sc_hd__decap_3
XPHY_EDGE_ROW_2_Left_30 VPWR VGND VPWR VGND sky130_fd_sc_hd__decap_3
XFILLER_18_6 VPWR VGND VPWR VGND sky130_fd_sc_hd__decap_3
XFILLER_18_130 VPWR VGND VPWR VGND sky130_fd_sc_hd__decap_3
XFILLER_18_141 VPWR VGND VPWR VGND sky130_fd_sc_hd__decap_3
XFILLER_18_174 VPWR VGND VPWR VGND sky130_fd_sc_hd__decap_3
XFILLER_24_177 VPWR VGND VPWR VGND sky130_fd_sc_hd__decap_3
XFILLER_24_144 VPWR VGND VPWR VGND sky130_fd_sc_hd__decap_3
XFILLER_24_133 VPWR VGND VPWR VGND sky130_fd_sc_hd__decap_3
XFILLER_24_100 VPWR VGND VPWR VGND sky130_fd_sc_hd__decap_3
XFILLER_21_33 VPWR VGND VPWR VGND sky130_fd_sc_hd__decap_3
XFILLER_21_66 VPWR VGND VPWR VGND sky130_fd_sc_hd__decap_3
XFILLER_21_99 VPWR VGND VPWR VGND sky130_fd_sc_hd__decap_3
XFILLER_15_122 VPWR VGND VPWR VGND sky130_fd_sc_hd__decap_3
XFILLER_15_155 VPWR VGND VPWR VGND sky130_fd_sc_hd__decap_3
XFILLER_7_24 VPWR VGND VPWR VGND sky130_fd_sc_hd__decap_3
XFILLER_7_57 VPWR VGND VPWR VGND sky130_fd_sc_hd__decap_3
XFILLER_16_3 VPWR VGND VPWR VGND sky130_fd_sc_hd__decap_3
XFILLER_21_125 VPWR VGND VPWR VGND sky130_fd_sc_hd__decap_3
XFILLER_21_158 VPWR VGND VPWR VGND sky130_fd_sc_hd__decap_3
XFILLER_21_169 VPWR VGND VPWR VGND sky130_fd_sc_hd__decap_3
XFILLER_8_118 VPWR VGND VPWR VGND sky130_fd_sc_hd__decap_3
XFILLER_12_103 VPWR VGND VPWR VGND sky130_fd_sc_hd__decap_3
XFILLER_12_136 VPWR VGND VPWR VGND sky130_fd_sc_hd__decap_3
XFILLER_12_147 VPWR VGND VPWR VGND sky130_fd_sc_hd__decap_3
XFILLER_16_44 VPWR VGND VPWR VGND sky130_fd_sc_hd__decap_3
XFILLER_16_77 VPWR VGND VPWR VGND sky130_fd_sc_hd__decap_3
XFILLER_16_88 VPWR VGND VPWR VGND sky130_fd_sc_hd__decap_3
XFILLER_20_180 VPWR VGND VPWR VGND sky130_fd_sc_hd__decap_3
XFILLER_7_140 VPWR VGND VPWR VGND sky130_fd_sc_hd__decap_3
XFILLER_7_184 VPWR VGND VPWR VGND sky130_fd_sc_hd__decap_3
XFILLER_27_32 VPWR VGND VPWR VGND sky130_fd_sc_hd__decap_3
XFILLER_27_21 VPWR VGND VPWR VGND sky130_fd_sc_hd__decap_3
XFILLER_4_165 VPWR VGND VPWR VGND sky130_fd_sc_hd__decap_3
XFILLER_4_121 VPWR VGND VPWR VGND sky130_fd_sc_hd__decap_3
XFILLER_4_47 VPWR VGND VPWR VGND sky130_fd_sc_hd__decap_3
XFILLER_13_12 VPWR VGND VPWR VGND sky130_fd_sc_hd__decap_3
XFILLER_13_45 VPWR VGND VPWR VGND sky130_fd_sc_hd__decap_3
XFILLER_1_113 VPWR VGND VPWR VGND sky130_fd_sc_hd__decap_3
XFILLER_13_78 VPWR VGND VPWR VGND sky130_fd_sc_hd__decap_3
XFILLER_1_146 VPWR VGND VPWR VGND sky130_fd_sc_hd__decap_3
XFILLER_5_90 VPWR VGND VPWR VGND sky130_fd_sc_hd__decap_3
XFILLER_24_88 VPWR VGND VPWR VGND sky130_fd_sc_hd__decap_3
XFILLER_24_77 VPWR VGND VPWR VGND sky130_fd_sc_hd__decap_3
XFILLER_24_44 VPWR VGND VPWR VGND sky130_fd_sc_hd__decap_3
XFILLER_1_15 VPWR VGND VPWR VGND sky130_fd_sc_hd__decap_3
XFILLER_1_48 VPWR VGND VPWR VGND sky130_fd_sc_hd__decap_3
XPHY_EDGE_ROW_18_Right_18 VPWR VGND VPWR VGND sky130_fd_sc_hd__decap_3
XPHY_EDGE_ROW_27_Right_27 VPWR VGND VPWR VGND sky130_fd_sc_hd__decap_3
XFILLER_10_24 VPWR VGND VPWR VGND sky130_fd_sc_hd__decap_3
XFILLER_10_35 VPWR VGND VPWR VGND sky130_fd_sc_hd__decap_3
XFILLER_10_68 VPWR VGND VPWR VGND sky130_fd_sc_hd__decap_3
XFILLER_27_153 VPWR VGND VPWR VGND sky130_fd_sc_hd__decap_3
XFILLER_27_131 VPWR VGND VPWR VGND sky130_fd_sc_hd__decap_3
XFILLER_19_33 VPWR VGND VPWR VGND sky130_fd_sc_hd__decap_3
XFILLER_19_66 VPWR VGND VPWR VGND sky130_fd_sc_hd__decap_3
XFILLER_19_99 VPWR VGND VPWR VGND sky130_fd_sc_hd__decap_3
XFILLER_27_175 VPWR VGND VPWR VGND sky130_fd_sc_hd__decap_3
XFILLER_18_153 VPWR VGND VPWR VGND sky130_fd_sc_hd__decap_3
XFILLER_18_186 VPWR VGND VPWR VGND sky130_fd_sc_hd__decap_3
XFILLER_2_91 VPWR VGND VPWR VGND sky130_fd_sc_hd__decap_3
XFILLER_2_80 VPWR VGND VPWR VGND sky130_fd_sc_hd__decap_3
XFILLER_24_156 VPWR VGND VPWR VGND sky130_fd_sc_hd__decap_3
XFILLER_24_112 VPWR VGND VPWR VGND sky130_fd_sc_hd__decap_3
XFILLER_21_12 VPWR VGND VPWR VGND sky130_fd_sc_hd__decap_3
XFILLER_21_45 VPWR VGND VPWR VGND sky130_fd_sc_hd__decap_3
XFILLER_21_78 VPWR VGND VPWR VGND sky130_fd_sc_hd__decap_3
XFILLER_15_134 VPWR VGND VPWR VGND sky130_fd_sc_hd__decap_3
XFILLER_7_36 VPWR VGND VPWR VGND sky130_fd_sc_hd__decap_3
XFILLER_15_178 VPWR VGND VPWR VGND sky130_fd_sc_hd__decap_3
XFILLER_7_69 VPWR VGND VPWR VGND sky130_fd_sc_hd__decap_3
XFILLER_21_137 VPWR VGND VPWR VGND sky130_fd_sc_hd__decap_3
XFILLER_16_12 VPWR VGND VPWR VGND sky130_fd_sc_hd__decap_3
XPHY_EDGE_ROW_0_Right_0 VPWR VGND VPWR VGND sky130_fd_sc_hd__decap_3
XFILLER_12_115 VPWR VGND VPWR VGND sky130_fd_sc_hd__decap_3
XFILLER_12_159 VPWR VGND VPWR VGND sky130_fd_sc_hd__decap_3
XFILLER_16_56 VPWR VGND VPWR VGND sky130_fd_sc_hd__decap_3
XFILLER_7_152 VPWR VGND VPWR VGND sky130_fd_sc_hd__decap_3
XFILLER_11_181 VPWR VGND VPWR VGND sky130_fd_sc_hd__decap_3
XFILLER_27_88 VPWR VGND VPWR VGND sky130_fd_sc_hd__decap_3
XFILLER_27_66 VPWR VGND VPWR VGND sky130_fd_sc_hd__decap_3
XFILLER_27_44 VPWR VGND VPWR VGND sky130_fd_sc_hd__decap_3
XFILLER_4_177 VPWR VGND VPWR VGND sky130_fd_sc_hd__decap_3
XFILLER_4_144 VPWR VGND VPWR VGND sky130_fd_sc_hd__decap_3
XFILLER_4_133 VPWR VGND VPWR VGND sky130_fd_sc_hd__decap_3
XFILLER_4_100 VPWR VGND VPWR VGND sky130_fd_sc_hd__decap_3
XFILLER_4_59 VPWR VGND VPWR VGND sky130_fd_sc_hd__decap_3
XFILLER_4_15 VPWR VGND VPWR VGND sky130_fd_sc_hd__decap_3
XFILLER_13_24 VPWR VGND VPWR VGND sky130_fd_sc_hd__decap_3
XFILLER_13_57 VPWR VGND VPWR VGND sky130_fd_sc_hd__decap_3
XFILLER_1_158 VPWR VGND VPWR VGND sky130_fd_sc_hd__decap_3
XFILLER_1_125 VPWR VGND VPWR VGND sky130_fd_sc_hd__decap_3
XFILLER_8_6 VPWR VGND VPWR VGND sky130_fd_sc_hd__decap_3
XFILLER_1_169 VPWR VGND VPWR VGND sky130_fd_sc_hd__decap_3
XFILLER_24_56 VPWR VGND VPWR VGND sky130_fd_sc_hd__decap_3
XFILLER_24_12 VPWR VGND VPWR VGND sky130_fd_sc_hd__decap_3
XFILLER_6_3 VPWR VGND VPWR VGND sky130_fd_sc_hd__decap_3
XFILLER_1_27 VPWR VGND VPWR VGND sky130_fd_sc_hd__decap_3
XFILLER_10_47 VPWR VGND VPWR VGND sky130_fd_sc_hd__decap_3
XFILLER_19_12 VPWR VGND VPWR VGND sky130_fd_sc_hd__decap_3
XFILLER_27_165 VPWR VGND VPWR VGND sky130_fd_sc_hd__decap_3
XFILLER_19_45 VPWR VGND VPWR VGND sky130_fd_sc_hd__decap_3
XFILLER_19_78 VPWR VGND VPWR VGND sky130_fd_sc_hd__decap_3
XFILLER_27_187 VPWR VGND VPWR VGND sky130_fd_sc_hd__decap_3
XFILLER_25_9 VPWR VGND VPWR VGND sky130_fd_sc_hd__decap_3
XFILLER_18_121 VPWR VGND VPWR VGND sky130_fd_sc_hd__decap_3
XFILLER_18_165 VPWR VGND VPWR VGND sky130_fd_sc_hd__decap_3
XFILLER_24_168 VPWR VGND VPWR VGND sky130_fd_sc_hd__decap_3
XFILLER_24_124 VPWR VGND VPWR VGND sky130_fd_sc_hd__decap_3
XFILLER_21_24 VPWR VGND VPWR VGND sky130_fd_sc_hd__decap_3
XFILLER_21_57 VPWR VGND VPWR VGND sky130_fd_sc_hd__decap_3
XFILLER_15_102 VPWR VGND VPWR VGND sky130_fd_sc_hd__decap_3
XFILLER_15_113 VPWR VGND VPWR VGND sky130_fd_sc_hd__decap_3
XFILLER_15_146 VPWR VGND VPWR VGND sky130_fd_sc_hd__decap_3
XFILLER_7_15 VPWR VGND VPWR VGND sky130_fd_sc_hd__decap_3
XFILLER_7_48 VPWR VGND VPWR VGND sky130_fd_sc_hd__decap_3
XFILLER_11_90 VPWR VGND VPWR VGND sky130_fd_sc_hd__decap_3
XFILLER_23_6 VPWR VGND VPWR VGND sky130_fd_sc_hd__decap_3
XFILLER_21_105 VPWR VGND VPWR VGND sky130_fd_sc_hd__decap_3
XFILLER_21_116 VPWR VGND VPWR VGND sky130_fd_sc_hd__decap_3
XFILLER_21_149 VPWR VGND VPWR VGND sky130_fd_sc_hd__decap_3
XFILLER_16_24 VPWR VGND VPWR VGND sky130_fd_sc_hd__decap_3
XFILLER_16_35 VPWR VGND VPWR VGND sky130_fd_sc_hd__decap_3
XFILLER_16_68 VPWR VGND VPWR VGND sky130_fd_sc_hd__decap_3
XFILLER_8_109 VPWR VGND VPWR VGND sky130_fd_sc_hd__decap_3
XFILLER_12_127 VPWR VGND VPWR VGND sky130_fd_sc_hd__decap_3
XFILLER_20_171 VPWR VGND VPWR VGND sky130_fd_sc_hd__decap_3
XFILLER_7_131 VPWR VGND VPWR VGND sky130_fd_sc_hd__decap_3
XFILLER_7_164 VPWR VGND VPWR VGND sky130_fd_sc_hd__decap_3
XFILLER_7_175 VPWR VGND VPWR VGND sky130_fd_sc_hd__decap_3
XFILLER_21_3 VPWR VGND VPWR VGND sky130_fd_sc_hd__decap_3
XFILLER_8_80 VPWR VGND VPWR VGND sky130_fd_sc_hd__decap_3
XFILLER_8_91 VPWR VGND VPWR VGND sky130_fd_sc_hd__decap_3
XFILLER_27_12 VPWR VGND VPWR VGND sky130_fd_sc_hd__decap_3
XFILLER_27_78 VPWR VGND VPWR VGND sky130_fd_sc_hd__decap_3
XFILLER_4_112 VPWR VGND VPWR VGND sky130_fd_sc_hd__decap_3
XFILLER_4_156 VPWR VGND VPWR VGND sky130_fd_sc_hd__decap_3
XFILLER_4_38 VPWR VGND VPWR VGND sky130_fd_sc_hd__decap_3
XPHY_EDGE_ROW_18_Left_46 VPWR VGND VPWR VGND sky130_fd_sc_hd__decap_3
XFILLER_13_36 VPWR VGND VPWR VGND sky130_fd_sc_hd__decap_3
XFILLER_13_69 VPWR VGND VPWR VGND sky130_fd_sc_hd__decap_3
XFILLER_1_137 VPWR VGND VPWR VGND sky130_fd_sc_hd__decap_3
XFILLER_0_181 VPWR VGND VPWR VGND sky130_fd_sc_hd__decap_3
XFILLER_5_81 VPWR VGND VPWR VGND sky130_fd_sc_hd__decap_3
XFILLER_24_68 VPWR VGND VPWR VGND sky130_fd_sc_hd__decap_3
XFILLER_24_35 VPWR VGND VPWR VGND sky130_fd_sc_hd__decap_3
XFILLER_24_24 VPWR VGND VPWR VGND sky130_fd_sc_hd__decap_3
XFILLER_1_39 VPWR VGND VPWR VGND sky130_fd_sc_hd__decap_3
XFILLER_10_15 VPWR VGND VPWR VGND sky130_fd_sc_hd__decap_3
XFILLER_10_59 VPWR VGND VPWR VGND sky130_fd_sc_hd__decap_3
XFILLER_19_24 VPWR VGND VPWR VGND sky130_fd_sc_hd__decap_3
XFILLER_27_144 VPWR VGND VPWR VGND sky130_fd_sc_hd__decap_3
XFILLER_27_122 VPWR VGND VPWR VGND sky130_fd_sc_hd__decap_3
XFILLER_27_100 VPWR VGND VPWR VGND sky130_fd_sc_hd__decap_3
XFILLER_19_57 VPWR VGND VPWR VGND sky130_fd_sc_hd__decap_3
XFILLER_18_9 VPWR VGND VPWR VGND sky130_fd_sc_hd__decap_3
XFILLER_18_100 VPWR VGND VPWR VGND sky130_fd_sc_hd__decap_3
XFILLER_18_133 VPWR VGND VPWR VGND sky130_fd_sc_hd__decap_3
XFILLER_18_144 VPWR VGND VPWR VGND sky130_fd_sc_hd__decap_3
XFILLER_18_177 VPWR VGND VPWR VGND sky130_fd_sc_hd__decap_3
XFILLER_24_103 VPWR VGND VPWR VGND sky130_fd_sc_hd__decap_3
XFILLER_2_71 VPWR VGND VPWR VGND sky130_fd_sc_hd__decap_3
XFILLER_24_147 VPWR VGND VPWR VGND sky130_fd_sc_hd__decap_3
XFILLER_24_136 VPWR VGND VPWR VGND sky130_fd_sc_hd__decap_3
XFILLER_21_36 VPWR VGND VPWR VGND sky130_fd_sc_hd__decap_3
XFILLER_21_69 VPWR VGND VPWR VGND sky130_fd_sc_hd__decap_3
XPHY_EDGE_ROW_6_Left_34 VPWR VGND VPWR VGND sky130_fd_sc_hd__decap_3
XFILLER_15_125 VPWR VGND VPWR VGND sky130_fd_sc_hd__decap_3
XFILLER_15_158 VPWR VGND VPWR VGND sky130_fd_sc_hd__decap_3
XFILLER_15_169 VPWR VGND VPWR VGND sky130_fd_sc_hd__decap_3
XFILLER_7_27 VPWR VGND VPWR VGND sky130_fd_sc_hd__decap_3
XFILLER_16_6 VPWR VGND VPWR VGND sky130_fd_sc_hd__decap_3
XFILLER_14_180 VPWR VGND VPWR VGND sky130_fd_sc_hd__decap_3
XFILLER_21_128 VPWR VGND VPWR VGND sky130_fd_sc_hd__decap_3
XFILLER_12_106 VPWR VGND VPWR VGND sky130_fd_sc_hd__decap_3
XFILLER_16_47 VPWR VGND VPWR VGND sky130_fd_sc_hd__decap_3
XFILLER_20_150 VPWR VGND VPWR VGND sky130_fd_sc_hd__decap_3
XFILLER_20_183 VPWR VGND VPWR VGND sky130_fd_sc_hd__decap_3
XFILLER_7_143 VPWR VGND VPWR VGND sky130_fd_sc_hd__decap_3
XFILLER_7_187 VPWR VGND VPWR VGND sky130_fd_sc_hd__decap_3
XFILLER_11_161 VPWR VGND VPWR VGND sky130_fd_sc_hd__decap_3
XFILLER_11_172 VPWR VGND VPWR VGND sky130_fd_sc_hd__decap_3
XFILLER_14_3 VPWR VGND VPWR VGND sky130_fd_sc_hd__decap_3
XFILLER_27_57 VPWR VGND VPWR VGND sky130_fd_sc_hd__decap_3
XFILLER_27_35 VPWR VGND VPWR VGND sky130_fd_sc_hd__decap_3
XFILLER_27_24 VPWR VGND VPWR VGND sky130_fd_sc_hd__decap_3
XFILLER_4_124 VPWR VGND VPWR VGND sky130_fd_sc_hd__decap_3
XFILLER_4_168 VPWR VGND VPWR VGND sky130_fd_sc_hd__decap_3
XFILLER_17_90 VPWR VGND VPWR VGND sky130_fd_sc_hd__decap_3
XFILLER_13_15 VPWR VGND VPWR VGND sky130_fd_sc_hd__decap_3
XFILLER_13_48 VPWR VGND VPWR VGND sky130_fd_sc_hd__decap_3
XFILLER_1_149 VPWR VGND VPWR VGND sky130_fd_sc_hd__decap_3
XFILLER_1_105 VPWR VGND VPWR VGND sky130_fd_sc_hd__decap_3
XFILLER_1_116 VPWR VGND VPWR VGND sky130_fd_sc_hd__decap_3
XFILLER_5_93 VPWR VGND VPWR VGND sky130_fd_sc_hd__decap_3
XFILLER_5_60 VPWR VGND VPWR VGND sky130_fd_sc_hd__decap_3
XFILLER_24_47 VPWR VGND VPWR VGND sky130_fd_sc_hd__decap_3
XFILLER_1_18 VPWR VGND VPWR VGND sky130_fd_sc_hd__decap_3
XFILLER_14_80 VPWR VGND VPWR VGND sky130_fd_sc_hd__decap_3
XFILLER_14_91 VPWR VGND VPWR VGND sky130_fd_sc_hd__decap_3
XFILLER_10_38 VPWR VGND VPWR VGND sky130_fd_sc_hd__decap_3
XFILLER_19_36 VPWR VGND VPWR VGND sky130_fd_sc_hd__decap_3
XFILLER_19_69 VPWR VGND VPWR VGND sky130_fd_sc_hd__decap_3
XFILLER_27_178 VPWR VGND VPWR VGND sky130_fd_sc_hd__decap_3
XFILLER_27_156 VPWR VGND VPWR VGND sky130_fd_sc_hd__decap_3
XFILLER_27_134 VPWR VGND VPWR VGND sky130_fd_sc_hd__decap_3
XPHY_EDGE_ROW_14_Right_14 VPWR VGND VPWR VGND sky130_fd_sc_hd__decap_3
XPHY_EDGE_ROW_23_Right_23 VPWR VGND VPWR VGND sky130_fd_sc_hd__decap_3
XFILLER_18_112 VPWR VGND VPWR VGND sky130_fd_sc_hd__decap_3
XFILLER_18_156 VPWR VGND VPWR VGND sky130_fd_sc_hd__decap_3
XFILLER_25_90 VPWR VGND VPWR VGND sky130_fd_sc_hd__decap_3
XFILLER_2_50 VPWR VGND VPWR VGND sky130_fd_sc_hd__decap_3
XPHY_EDGE_ROW_22_Left_50 VPWR VGND VPWR VGND sky130_fd_sc_hd__decap_3
XFILLER_24_159 VPWR VGND VPWR VGND sky130_fd_sc_hd__decap_3
XFILLER_24_115 VPWR VGND VPWR VGND sky130_fd_sc_hd__decap_3
XFILLER_21_15 VPWR VGND VPWR VGND sky130_fd_sc_hd__decap_3
XFILLER_21_48 VPWR VGND VPWR VGND sky130_fd_sc_hd__decap_3
XFILLER_23_181 VPWR VGND VPWR VGND sky130_fd_sc_hd__decap_3
XFILLER_15_137 VPWR VGND VPWR VGND sky130_fd_sc_hd__decap_3
XFILLER_7_39 VPWR VGND VPWR VGND sky130_fd_sc_hd__decap_3
XFILLER_11_81 VPWR VGND VPWR VGND sky130_fd_sc_hd__decap_3
XFILLER_12_118 VPWR VGND VPWR VGND sky130_fd_sc_hd__decap_3
XFILLER_16_15 VPWR VGND VPWR VGND sky130_fd_sc_hd__decap_3
XFILLER_16_59 VPWR VGND VPWR VGND sky130_fd_sc_hd__decap_3
XFILLER_20_162 VPWR VGND VPWR VGND sky130_fd_sc_hd__decap_3
XFILLER_7_122 VPWR VGND VPWR VGND sky130_fd_sc_hd__decap_3
XFILLER_11_140 VPWR VGND VPWR VGND sky130_fd_sc_hd__decap_3
XFILLER_22_91 VPWR VGND VPWR VGND sky130_fd_sc_hd__decap_3
XFILLER_7_155 VPWR VGND VPWR VGND sky130_fd_sc_hd__decap_3
XFILLER_11_184 VPWR VGND VPWR VGND sky130_fd_sc_hd__decap_3
XFILLER_22_80 VPWR VGND VPWR VGND sky130_fd_sc_hd__decap_3
XFILLER_8_71 VPWR VGND VPWR VGND sky130_fd_sc_hd__decap_3
XPHY_EDGE_ROW_4_Right_4 VPWR VGND VPWR VGND sky130_fd_sc_hd__decap_3
XFILLER_27_69 VPWR VGND VPWR VGND sky130_fd_sc_hd__decap_3
XFILLER_27_47 VPWR VGND VPWR VGND sky130_fd_sc_hd__decap_3
XFILLER_4_147 VPWR VGND VPWR VGND sky130_fd_sc_hd__decap_3
XFILLER_4_136 VPWR VGND VPWR VGND sky130_fd_sc_hd__decap_3
XFILLER_4_103 VPWR VGND VPWR VGND sky130_fd_sc_hd__decap_3
XFILLER_4_29 VPWR VGND VPWR VGND sky130_fd_sc_hd__decap_3
XFILLER_4_18 VPWR VGND VPWR VGND sky130_fd_sc_hd__decap_3
XFILLER_13_27 VPWR VGND VPWR VGND sky130_fd_sc_hd__decap_3
XFILLER_1_128 VPWR VGND VPWR VGND sky130_fd_sc_hd__decap_3
XFILLER_8_9 VPWR VGND VPWR VGND sky130_fd_sc_hd__decap_3
XFILLER_0_172 VPWR VGND VPWR VGND sky130_fd_sc_hd__decap_3
XFILLER_0_150 VPWR VGND VPWR VGND sky130_fd_sc_hd__decap_3
XFILLER_5_72 VPWR VGND VPWR VGND sky130_fd_sc_hd__decap_3
XFILLER_24_15 VPWR VGND VPWR VGND sky130_fd_sc_hd__decap_3
XFILLER_24_59 VPWR VGND VPWR VGND sky130_fd_sc_hd__decap_3
XFILLER_6_6 VPWR VGND VPWR VGND sky130_fd_sc_hd__decap_3
XFILLER_27_113 VPWR VGND VPWR VGND sky130_fd_sc_hd__decap_3
XFILLER_19_15 VPWR VGND VPWR VGND sky130_fd_sc_hd__decap_3
XFILLER_19_48 VPWR VGND VPWR VGND sky130_fd_sc_hd__decap_3
XFILLER_4_3 VPWR VGND VPWR VGND sky130_fd_sc_hd__decap_3
XFILLER_18_124 VPWR VGND VPWR VGND sky130_fd_sc_hd__decap_3
XFILLER_18_168 VPWR VGND VPWR VGND sky130_fd_sc_hd__decap_3
XFILLER_2_62 VPWR VGND VPWR VGND sky130_fd_sc_hd__decap_3
XFILLER_24_127 VPWR VGND VPWR VGND sky130_fd_sc_hd__decap_3
XFILLER_21_27 VPWR VGND VPWR VGND sky130_fd_sc_hd__decap_3
XFILLER_15_105 VPWR VGND VPWR VGND sky130_fd_sc_hd__decap_3
XFILLER_15_116 VPWR VGND VPWR VGND sky130_fd_sc_hd__decap_3
XFILLER_7_18 VPWR VGND VPWR VGND sky130_fd_sc_hd__decap_3
XFILLER_15_149 VPWR VGND VPWR VGND sky130_fd_sc_hd__decap_3
XFILLER_11_60 VPWR VGND VPWR VGND sky130_fd_sc_hd__decap_3
XFILLER_11_93 VPWR VGND VPWR VGND sky130_fd_sc_hd__decap_3
XFILLER_23_9 VPWR VGND VPWR VGND sky130_fd_sc_hd__decap_3
XFILLER_21_108 VPWR VGND VPWR VGND sky130_fd_sc_hd__decap_3
XFILLER_14_171 VPWR VGND VPWR VGND sky130_fd_sc_hd__decap_3
XFILLER_21_119 VPWR VGND VPWR VGND sky130_fd_sc_hd__decap_3
XFILLER_16_38 VPWR VGND VPWR VGND sky130_fd_sc_hd__decap_3
XFILLER_20_130 VPWR VGND VPWR VGND sky130_fd_sc_hd__decap_3
XFILLER_20_141 VPWR VGND VPWR VGND sky130_fd_sc_hd__decap_3
XFILLER_20_174 VPWR VGND VPWR VGND sky130_fd_sc_hd__decap_3
XFILLER_7_134 VPWR VGND VPWR VGND sky130_fd_sc_hd__decap_3
XFILLER_11_152 VPWR VGND VPWR VGND sky130_fd_sc_hd__decap_3
XFILLER_7_178 VPWR VGND VPWR VGND sky130_fd_sc_hd__decap_3
XFILLER_21_6 VPWR VGND VPWR VGND sky130_fd_sc_hd__decap_3
XFILLER_8_50 VPWR VGND VPWR VGND sky130_fd_sc_hd__decap_3
XFILLER_8_94 VPWR VGND VPWR VGND sky130_fd_sc_hd__decap_3
XFILLER_27_15 VPWR VGND VPWR VGND sky130_fd_sc_hd__decap_3
XFILLER_4_159 VPWR VGND VPWR VGND sky130_fd_sc_hd__decap_3
XFILLER_4_115 VPWR VGND VPWR VGND sky130_fd_sc_hd__decap_3
XFILLER_17_81 VPWR VGND VPWR VGND sky130_fd_sc_hd__decap_3
XFILLER_3_181 VPWR VGND VPWR VGND sky130_fd_sc_hd__decap_3
XFILLER_13_39 VPWR VGND VPWR VGND sky130_fd_sc_hd__decap_3
XFILLER_0_162 VPWR VGND VPWR VGND sky130_fd_sc_hd__decap_3
XFILLER_0_184 VPWR VGND VPWR VGND sky130_fd_sc_hd__decap_3
XFILLER_5_51 VPWR VGND VPWR VGND sky130_fd_sc_hd__decap_3
XFILLER_5_84 VPWR VGND VPWR VGND sky130_fd_sc_hd__decap_3
XFILLER_24_38 VPWR VGND VPWR VGND sky130_fd_sc_hd__decap_3
XFILLER_14_71 VPWR VGND VPWR VGND sky130_fd_sc_hd__decap_3
XFILLER_10_18 VPWR VGND VPWR VGND sky130_fd_sc_hd__decap_3
XFILLER_10_29 VPWR VGND VPWR VGND sky130_fd_sc_hd__decap_3
XFILLER_27_147 VPWR VGND VPWR VGND sky130_fd_sc_hd__decap_3
XFILLER_27_125 VPWR VGND VPWR VGND sky130_fd_sc_hd__decap_3
XFILLER_27_103 VPWR VGND VPWR VGND sky130_fd_sc_hd__decap_3
XFILLER_19_27 VPWR VGND VPWR VGND sky130_fd_sc_hd__decap_3
XFILLER_27_169 VPWR VGND VPWR VGND sky130_fd_sc_hd__decap_3
XFILLER_26_180 VPWR VGND VPWR VGND sky130_fd_sc_hd__decap_3
XFILLER_18_103 VPWR VGND VPWR VGND sky130_fd_sc_hd__decap_3
XFILLER_18_136 VPWR VGND VPWR VGND sky130_fd_sc_hd__decap_3
XFILLER_18_147 VPWR VGND VPWR VGND sky130_fd_sc_hd__decap_3
XFILLER_25_81 VPWR VGND VPWR VGND sky130_fd_sc_hd__decap_3
XFILLER_2_85 VPWR VGND VPWR VGND sky130_fd_sc_hd__decap_3
XFILLER_2_74 VPWR VGND VPWR VGND sky130_fd_sc_hd__decap_3
XFILLER_2_41 VPWR VGND VPWR VGND sky130_fd_sc_hd__decap_3
XFILLER_24_106 VPWR VGND VPWR VGND sky130_fd_sc_hd__decap_3
XFILLER_21_39 VPWR VGND VPWR VGND sky130_fd_sc_hd__decap_3
XFILLER_15_128 VPWR VGND VPWR VGND sky130_fd_sc_hd__decap_3
XFILLER_23_172 VPWR VGND VPWR VGND sky130_fd_sc_hd__decap_3
XFILLER_23_161 VPWR VGND VPWR VGND sky130_fd_sc_hd__decap_3
XFILLER_11_72 VPWR VGND VPWR VGND sky130_fd_sc_hd__decap_3
XFILLER_16_9 VPWR VGND VPWR VGND sky130_fd_sc_hd__decap_3
XFILLER_14_150 VPWR VGND VPWR VGND sky130_fd_sc_hd__decap_3
XFILLER_14_183 VPWR VGND VPWR VGND sky130_fd_sc_hd__decap_3
XFILLER_12_109 VPWR VGND VPWR VGND sky130_fd_sc_hd__decap_3
XFILLER_20_153 VPWR VGND VPWR VGND sky130_fd_sc_hd__decap_3
XFILLER_20_186 VPWR VGND VPWR VGND sky130_fd_sc_hd__decap_3
XFILLER_7_102 VPWR VGND VPWR VGND sky130_fd_sc_hd__decap_3
XFILLER_7_113 VPWR VGND VPWR VGND sky130_fd_sc_hd__decap_3
XFILLER_7_146 VPWR VGND VPWR VGND sky130_fd_sc_hd__decap_3
XFILLER_11_131 VPWR VGND VPWR VGND sky130_fd_sc_hd__decap_3
XFILLER_11_164 VPWR VGND VPWR VGND sky130_fd_sc_hd__decap_3
XFILLER_11_175 VPWR VGND VPWR VGND sky130_fd_sc_hd__decap_3
XFILLER_22_71 VPWR VGND VPWR VGND sky130_fd_sc_hd__decap_3
XFILLER_14_6 VPWR VGND VPWR VGND sky130_fd_sc_hd__decap_3
XFILLER_8_62 VPWR VGND VPWR VGND sky130_fd_sc_hd__decap_3
XFILLER_27_38 VPWR VGND VPWR VGND sky130_fd_sc_hd__decap_3
XFILLER_4_127 VPWR VGND VPWR VGND sky130_fd_sc_hd__decap_3
XFILLER_17_60 VPWR VGND VPWR VGND sky130_fd_sc_hd__decap_3
XFILLER_17_93 VPWR VGND VPWR VGND sky130_fd_sc_hd__decap_3
XFILLER_12_3 VPWR VGND VPWR VGND sky130_fd_sc_hd__decap_3
XFILLER_13_18 VPWR VGND VPWR VGND sky130_fd_sc_hd__decap_3
XFILLER_1_108 VPWR VGND VPWR VGND sky130_fd_sc_hd__decap_3
XFILLER_1_119 VPWR VGND VPWR VGND sky130_fd_sc_hd__decap_3
XFILLER_0_141 VPWR VGND VPWR VGND sky130_fd_sc_hd__decap_3
XFILLER_5_96 VPWR VGND VPWR VGND sky130_fd_sc_hd__decap_3
XFILLER_5_63 VPWR VGND VPWR VGND sky130_fd_sc_hd__decap_3
XFILLER_5_30 VPWR VGND VPWR VGND sky130_fd_sc_hd__decap_3
XFILLER_14_50 VPWR VGND VPWR VGND sky130_fd_sc_hd__decap_3
XFILLER_14_94 VPWR VGND VPWR VGND sky130_fd_sc_hd__decap_3
XFILLER_27_159 VPWR VGND VPWR VGND sky130_fd_sc_hd__decap_3
XFILLER_27_137 VPWR VGND VPWR VGND sky130_fd_sc_hd__decap_3
XFILLER_19_39 VPWR VGND VPWR VGND sky130_fd_sc_hd__decap_3
XFILLER_18_115 VPWR VGND VPWR VGND sky130_fd_sc_hd__decap_3
XFILLER_25_60 VPWR VGND VPWR VGND sky130_fd_sc_hd__decap_3
XFILLER_18_159 VPWR VGND VPWR VGND sky130_fd_sc_hd__decap_3
XFILLER_25_93 VPWR VGND VPWR VGND sky130_fd_sc_hd__decap_3
XFILLER_2_53 VPWR VGND VPWR VGND sky130_fd_sc_hd__decap_3
XPHY_EDGE_ROW_10_Right_10 VPWR VGND VPWR VGND sky130_fd_sc_hd__decap_3
XFILLER_24_118 VPWR VGND VPWR VGND sky130_fd_sc_hd__decap_3
XFILLER_17_181 VPWR VGND VPWR VGND sky130_fd_sc_hd__decap_3
XFILLER_21_18 VPWR VGND VPWR VGND sky130_fd_sc_hd__decap_3
XFILLER_23_140 VPWR VGND VPWR VGND sky130_fd_sc_hd__decap_3
XFILLER_23_184 VPWR VGND VPWR VGND sky130_fd_sc_hd__decap_3
XFILLER_11_51 VPWR VGND VPWR VGND sky130_fd_sc_hd__decap_3
XFILLER_11_84 VPWR VGND VPWR VGND sky130_fd_sc_hd__decap_3
XPHY_EDGE_ROW_26_Left_54 VPWR VGND VPWR VGND sky130_fd_sc_hd__decap_3
XFILLER_14_162 VPWR VGND VPWR VGND sky130_fd_sc_hd__decap_3
XPHY_EDGE_ROW_10_Left_38 VPWR VGND VPWR VGND sky130_fd_sc_hd__decap_3
XFILLER_16_18 VPWR VGND VPWR VGND sky130_fd_sc_hd__decap_3
XFILLER_16_29 VPWR VGND VPWR VGND sky130_fd_sc_hd__decap_3
XFILLER_20_121 VPWR VGND VPWR VGND sky130_fd_sc_hd__decap_3
XFILLER_20_165 VPWR VGND VPWR VGND sky130_fd_sc_hd__decap_3
XFILLER_22_94 VPWR VGND VPWR VGND sky130_fd_sc_hd__decap_3
XFILLER_7_125 VPWR VGND VPWR VGND sky130_fd_sc_hd__decap_3
XFILLER_7_158 VPWR VGND VPWR VGND sky130_fd_sc_hd__decap_3
XFILLER_7_169 VPWR VGND VPWR VGND sky130_fd_sc_hd__decap_3
XFILLER_11_143 VPWR VGND VPWR VGND sky130_fd_sc_hd__decap_3
XFILLER_11_187 VPWR VGND VPWR VGND sky130_fd_sc_hd__decap_3
XFILLER_22_50 VPWR VGND VPWR VGND sky130_fd_sc_hd__decap_3
XFILLER_8_41 VPWR VGND VPWR VGND sky130_fd_sc_hd__decap_3
XFILLER_8_74 VPWR VGND VPWR VGND sky130_fd_sc_hd__decap_3
XFILLER_8_85 VPWR VGND VPWR VGND sky130_fd_sc_hd__decap_3
XFILLER_6_180 VPWR VGND VPWR VGND sky130_fd_sc_hd__decap_3
XFILLER_4_106 VPWR VGND VPWR VGND sky130_fd_sc_hd__decap_3
XFILLER_17_72 VPWR VGND VPWR VGND sky130_fd_sc_hd__decap_3
XFILLER_3_172 VPWR VGND VPWR VGND sky130_fd_sc_hd__decap_3
XFILLER_3_161 VPWR VGND VPWR VGND sky130_fd_sc_hd__decap_3
XPHY_EDGE_ROW_8_Right_8 VPWR VGND VPWR VGND sky130_fd_sc_hd__decap_3
XPHY_EDGE_ROW_13_Left_41 VPWR VGND VPWR VGND sky130_fd_sc_hd__decap_3
XFILLER_0_175 VPWR VGND VPWR VGND sky130_fd_sc_hd__decap_3
XFILLER_0_153 VPWR VGND VPWR VGND sky130_fd_sc_hd__decap_3
XFILLER_0_131 VPWR VGND VPWR VGND sky130_fd_sc_hd__decap_3
XFILLER_5_75 VPWR VGND VPWR VGND sky130_fd_sc_hd__decap_3
XFILLER_5_42 VPWR VGND VPWR VGND sky130_fd_sc_hd__decap_3
XFILLER_24_29 VPWR VGND VPWR VGND sky130_fd_sc_hd__decap_3
XFILLER_24_18 VPWR VGND VPWR VGND sky130_fd_sc_hd__decap_3
XFILLER_6_9 VPWR VGND VPWR VGND sky130_fd_sc_hd__decap_3
XFILLER_14_62 VPWR VGND VPWR VGND sky130_fd_sc_hd__decap_3
Xu_inv0 VPWR VGND VGND VPWR u_nand/Y u_inv1/A sky130_fd_sc_hd__inv_1
XFILLER_19_18 VPWR VGND VPWR VGND sky130_fd_sc_hd__decap_3
XFILLER_27_116 VPWR VGND VPWR VGND sky130_fd_sc_hd__decap_3
XFILLER_4_6 VPWR VGND VPWR VGND sky130_fd_sc_hd__decap_3
XFILLER_18_127 VPWR VGND VPWR VGND sky130_fd_sc_hd__decap_3
XFILLER_26_171 VPWR VGND VPWR VGND sky130_fd_sc_hd__decap_3
XFILLER_25_72 VPWR VGND VPWR VGND sky130_fd_sc_hd__decap_3
XFILLER_2_32 VPWR VGND VPWR VGND sky130_fd_sc_hd__decap_3
XFILLER_2_21 VPWR VGND VPWR VGND sky130_fd_sc_hd__decap_3
XFILLER_2_98 VPWR VGND VPWR VGND sky130_fd_sc_hd__decap_3
XFILLER_2_65 VPWR VGND VPWR VGND sky130_fd_sc_hd__decap_3
XFILLER_23_152 VPWR VGND VPWR VGND sky130_fd_sc_hd__decap_3
XFILLER_15_108 VPWR VGND VPWR VGND sky130_fd_sc_hd__decap_3
XFILLER_15_119 VPWR VGND VPWR VGND sky130_fd_sc_hd__decap_3
XFILLER_11_30 VPWR VGND VPWR VGND sky130_fd_sc_hd__decap_3
XFILLER_2_3 VPWR VGND VPWR VGND sky130_fd_sc_hd__decap_3
XFILLER_11_63 VPWR VGND VPWR VGND sky130_fd_sc_hd__decap_3
XFILLER_11_96 VPWR VGND VPWR VGND sky130_fd_sc_hd__decap_3
XFILLER_14_130 VPWR VGND VPWR VGND sky130_fd_sc_hd__decap_3
XFILLER_14_141 VPWR VGND VPWR VGND sky130_fd_sc_hd__decap_3
XFILLER_14_174 VPWR VGND VPWR VGND sky130_fd_sc_hd__decap_3
Xu_buf VPWR VGND u_buf/X u_buf/A VPWR VGND u_buf/a_27_47# sky130_fd_sc_hd__buf_2
XFILLER_20_100 VPWR VGND VPWR VGND sky130_fd_sc_hd__decap_3
XFILLER_20_133 VPWR VGND VPWR VGND sky130_fd_sc_hd__decap_3
XFILLER_20_144 VPWR VGND VPWR VGND sky130_fd_sc_hd__decap_3
XFILLER_20_177 VPWR VGND VPWR VGND sky130_fd_sc_hd__decap_3
XFILLER_11_122 VPWR VGND VPWR VGND sky130_fd_sc_hd__decap_3
XFILLER_11_155 VPWR VGND VPWR VGND sky130_fd_sc_hd__decap_3
XFILLER_7_137 VPWR VGND VPWR VGND sky130_fd_sc_hd__decap_3
XFILLER_22_62 VPWR VGND VPWR VGND sky130_fd_sc_hd__decap_3
XFILLER_21_9 VPWR VGND VPWR VGND sky130_fd_sc_hd__decap_3
XFILLER_8_53 VPWR VGND VPWR VGND sky130_fd_sc_hd__decap_3
XFILLER_8_97 VPWR VGND VPWR VGND sky130_fd_sc_hd__decap_3
XFILLER_27_29 VPWR VGND VPWR VGND sky130_fd_sc_hd__decap_3
XFILLER_27_18 VPWR VGND VPWR VGND sky130_fd_sc_hd__decap_3
XFILLER_4_118 VPWR VGND VPWR VGND sky130_fd_sc_hd__decap_3
XFILLER_17_51 VPWR VGND VPWR VGND sky130_fd_sc_hd__decap_3
XFILLER_17_84 VPWR VGND VPWR VGND sky130_fd_sc_hd__decap_3
XFILLER_3_184 VPWR VGND VPWR VGND sky130_fd_sc_hd__decap_3
XFILLER_3_140 VPWR VGND VPWR VGND sky130_fd_sc_hd__decap_3
XFILLER_0_187 VPWR VGND VPWR VGND sky130_fd_sc_hd__decap_3
XFILLER_0_165 VPWR VGND VPWR VGND sky130_fd_sc_hd__decap_3
XFILLER_5_21 VPWR VGND VPWR VGND sky130_fd_sc_hd__decap_3
XFILLER_5_87 VPWR VGND VPWR VGND sky130_fd_sc_hd__decap_3
XFILLER_14_41 VPWR VGND VPWR VGND sky130_fd_sc_hd__decap_3
XFILLER_14_74 VPWR VGND VPWR VGND sky130_fd_sc_hd__decap_3
XFILLER_14_85 VPWR VGND VPWR VGND sky130_fd_sc_hd__decap_3
Xu_inv1 VPWR VGND VGND VPWR u_inv1/A u_inv2/A sky130_fd_sc_hd__inv_1
XFILLER_27_106 VPWR VGND VPWR VGND sky130_fd_sc_hd__decap_3
XFILLER_27_128 VPWR VGND VPWR VGND sky130_fd_sc_hd__decap_3
XFILLER_18_106 VPWR VGND VPWR VGND sky130_fd_sc_hd__decap_3
XFILLER_26_183 VPWR VGND VPWR VGND sky130_fd_sc_hd__decap_3
XFILLER_26_150 VPWR VGND VPWR VGND sky130_fd_sc_hd__decap_3
XFILLER_25_84 VPWR VGND VPWR VGND sky130_fd_sc_hd__decap_3
XFILLER_25_51 VPWR VGND VPWR VGND sky130_fd_sc_hd__decap_3
XFILLER_2_77 VPWR VGND VPWR VGND sky130_fd_sc_hd__decap_3
XFILLER_2_44 VPWR VGND VPWR VGND sky130_fd_sc_hd__decap_3
XFILLER_24_109 VPWR VGND VPWR VGND sky130_fd_sc_hd__decap_3
XFILLER_2_88 VPWR VGND VPWR VGND sky130_fd_sc_hd__decap_3
XFILLER_17_161 VPWR VGND VPWR VGND sky130_fd_sc_hd__decap_3
XFILLER_17_172 VPWR VGND VPWR VGND sky130_fd_sc_hd__decap_3
XFILLER_23_175 VPWR VGND VPWR VGND sky130_fd_sc_hd__decap_3
XFILLER_23_164 VPWR VGND VPWR VGND sky130_fd_sc_hd__decap_3
XFILLER_23_131 VPWR VGND VPWR VGND sky130_fd_sc_hd__decap_3
XFILLER_11_42 VPWR VGND VPWR VGND sky130_fd_sc_hd__decap_3
XFILLER_11_75 VPWR VGND VPWR VGND sky130_fd_sc_hd__decap_3
XFILLER_14_153 VPWR VGND VPWR VGND sky130_fd_sc_hd__decap_3
XFILLER_14_186 VPWR VGND VPWR VGND sky130_fd_sc_hd__decap_3
XFILLER_20_112 VPWR VGND VPWR VGND sky130_fd_sc_hd__decap_3
XFILLER_20_156 VPWR VGND VPWR VGND sky130_fd_sc_hd__decap_3
XFILLER_7_105 VPWR VGND VPWR VGND sky130_fd_sc_hd__decap_3
XFILLER_7_116 VPWR VGND VPWR VGND sky130_fd_sc_hd__decap_3
XFILLER_11_134 VPWR VGND VPWR VGND sky130_fd_sc_hd__decap_3
XFILLER_11_178 VPWR VGND VPWR VGND sky130_fd_sc_hd__decap_3
XFILLER_22_41 VPWR VGND VPWR VGND sky130_fd_sc_hd__decap_3
XFILLER_7_149 VPWR VGND VPWR VGND sky130_fd_sc_hd__decap_3
XFILLER_22_74 VPWR VGND VPWR VGND sky130_fd_sc_hd__decap_3
XFILLER_22_85 VPWR VGND VPWR VGND sky130_fd_sc_hd__decap_3
XFILLER_14_9 VPWR VGND VPWR VGND sky130_fd_sc_hd__decap_3
XFILLER_6_171 VPWR VGND VPWR VGND sky130_fd_sc_hd__decap_3
XFILLER_8_21 VPWR VGND VPWR VGND sky130_fd_sc_hd__decap_3
XFILLER_8_32 VPWR VGND VPWR VGND sky130_fd_sc_hd__decap_3
XFILLER_8_65 VPWR VGND VPWR VGND sky130_fd_sc_hd__decap_3
XFILLER_17_30 VPWR VGND VPWR VGND sky130_fd_sc_hd__decap_3
XFILLER_17_63 VPWR VGND VPWR VGND sky130_fd_sc_hd__decap_3
XFILLER_17_96 VPWR VGND VPWR VGND sky130_fd_sc_hd__decap_3
XFILLER_3_152 VPWR VGND VPWR VGND sky130_fd_sc_hd__decap_3
XFILLER_12_6 VPWR VGND VPWR VGND sky130_fd_sc_hd__decap_3
XFILLER_0_144 VPWR VGND VPWR VGND sky130_fd_sc_hd__decap_3
XFILLER_0_122 VPWR VGND VPWR VGND sky130_fd_sc_hd__decap_3
XFILLER_5_33 VPWR VGND VPWR VGND sky130_fd_sc_hd__decap_3
XFILLER_5_99 VPWR VGND VPWR VGND sky130_fd_sc_hd__decap_3
XFILLER_5_66 VPWR VGND VPWR VGND sky130_fd_sc_hd__decap_3
XFILLER_10_3 VPWR VGND VPWR VGND sky130_fd_sc_hd__decap_3
XFILLER_14_53 VPWR VGND VPWR VGND sky130_fd_sc_hd__decap_3
XFILLER_14_97 VPWR VGND VPWR VGND sky130_fd_sc_hd__decap_3
Xu_inv2 VPWR VGND VGND VPWR u_inv2/A u_inv3/A sky130_fd_sc_hd__inv_1
XFILLER_26_162 VPWR VGND VPWR VGND sky130_fd_sc_hd__decap_3
XFILLER_25_30 VPWR VGND VPWR VGND sky130_fd_sc_hd__decap_3
XFILLER_18_118 VPWR VGND VPWR VGND sky130_fd_sc_hd__decap_3
XFILLER_25_96 VPWR VGND VPWR VGND sky130_fd_sc_hd__decap_3
XFILLER_25_63 VPWR VGND VPWR VGND sky130_fd_sc_hd__decap_3
XFILLER_2_56 VPWR VGND VPWR VGND sky130_fd_sc_hd__decap_3
XFILLER_2_12 VPWR VGND VPWR VGND sky130_fd_sc_hd__decap_3
XFILLER_17_140 VPWR VGND VPWR VGND sky130_fd_sc_hd__decap_3
XFILLER_17_184 VPWR VGND VPWR VGND sky130_fd_sc_hd__decap_3
XFILLER_23_187 VPWR VGND VPWR VGND sky130_fd_sc_hd__decap_3
XFILLER_23_143 VPWR VGND VPWR VGND sky130_fd_sc_hd__decap_3
XFILLER_11_21 VPWR VGND VPWR VGND sky130_fd_sc_hd__decap_3
XFILLER_11_87 VPWR VGND VPWR VGND sky130_fd_sc_hd__decap_3
XFILLER_14_121 VPWR VGND VPWR VGND sky130_fd_sc_hd__decap_3
XFILLER_14_165 VPWR VGND VPWR VGND sky130_fd_sc_hd__decap_3
XFILLER_20_124 VPWR VGND VPWR VGND sky130_fd_sc_hd__decap_3
XFILLER_20_168 VPWR VGND VPWR VGND sky130_fd_sc_hd__decap_3
XFILLER_7_128 VPWR VGND VPWR VGND sky130_fd_sc_hd__decap_3
XFILLER_11_102 VPWR VGND VPWR VGND sky130_fd_sc_hd__decap_3
XFILLER_11_113 VPWR VGND VPWR VGND sky130_fd_sc_hd__decap_3
XFILLER_11_146 VPWR VGND VPWR VGND sky130_fd_sc_hd__decap_3
XFILLER_22_53 VPWR VGND VPWR VGND sky130_fd_sc_hd__decap_3
XFILLER_22_97 VPWR VGND VPWR VGND sky130_fd_sc_hd__decap_3
XFILLER_6_150 VPWR VGND VPWR VGND sky130_fd_sc_hd__decap_3
XFILLER_6_183 VPWR VGND VPWR VGND sky130_fd_sc_hd__decap_3
XFILLER_8_44 VPWR VGND VPWR VGND sky130_fd_sc_hd__decap_3
XFILLER_8_77 VPWR VGND VPWR VGND sky130_fd_sc_hd__decap_3
XFILLER_8_88 VPWR VGND VPWR VGND sky130_fd_sc_hd__decap_3
XFILLER_4_109 VPWR VGND VPWR VGND sky130_fd_sc_hd__decap_3
XFILLER_17_42 VPWR VGND VPWR VGND sky130_fd_sc_hd__decap_3
XFILLER_17_75 VPWR VGND VPWR VGND sky130_fd_sc_hd__decap_3
XFILLER_3_175 VPWR VGND VPWR VGND sky130_fd_sc_hd__decap_3
XFILLER_3_164 VPWR VGND VPWR VGND sky130_fd_sc_hd__decap_3
XFILLER_3_131 VPWR VGND VPWR VGND sky130_fd_sc_hd__decap_3
XPHY_EDGE_ROW_17_Right_17 VPWR VGND VPWR VGND sky130_fd_sc_hd__decap_3
XPHY_EDGE_ROW_26_Right_26 VPWR VGND VPWR VGND sky130_fd_sc_hd__decap_3
XFILLER_0_178 VPWR VGND VPWR VGND sky130_fd_sc_hd__decap_3
XFILLER_0_156 VPWR VGND VPWR VGND sky130_fd_sc_hd__decap_3
XFILLER_0_134 VPWR VGND VPWR VGND sky130_fd_sc_hd__decap_3
XFILLER_5_78 VPWR VGND VPWR VGND sky130_fd_sc_hd__decap_3
XFILLER_5_45 VPWR VGND VPWR VGND sky130_fd_sc_hd__decap_3
XFILLER_5_12 VPWR VGND VPWR VGND sky130_fd_sc_hd__decap_3
XPHY_EDGE_ROW_17_Left_45 VPWR VGND VPWR VGND sky130_fd_sc_hd__decap_3
XFILLER_14_21 VPWR VGND VPWR VGND sky130_fd_sc_hd__decap_3
XFILLER_14_32 VPWR VGND VPWR VGND sky130_fd_sc_hd__decap_3
XFILLER_14_65 VPWR VGND VPWR VGND sky130_fd_sc_hd__decap_3
Xu_inv3 VPWR VGND VGND VPWR u_inv3/A u_buf/A sky130_fd_sc_hd__inv_1
XFILLER_27_119 VPWR VGND VPWR VGND sky130_fd_sc_hd__decap_3
XFILLER_4_9 VPWR VGND VPWR VGND sky130_fd_sc_hd__decap_3
XFILLER_26_174 VPWR VGND VPWR VGND sky130_fd_sc_hd__decap_3
XFILLER_26_141 VPWR VGND VPWR VGND sky130_fd_sc_hd__decap_3
XFILLER_26_130 VPWR VGND VPWR VGND sky130_fd_sc_hd__decap_3
XFILLER_25_42 VPWR VGND VPWR VGND sky130_fd_sc_hd__decap_3
XFILLER_25_75 VPWR VGND VPWR VGND sky130_fd_sc_hd__decap_3
XFILLER_2_68 VPWR VGND VPWR VGND sky130_fd_sc_hd__decap_3
XFILLER_2_35 VPWR VGND VPWR VGND sky130_fd_sc_hd__decap_3
XFILLER_2_24 VPWR VGND VPWR VGND sky130_fd_sc_hd__decap_3
XFILLER_17_152 VPWR VGND VPWR VGND sky130_fd_sc_hd__decap_3
XFILLER_23_122 VPWR VGND VPWR VGND sky130_fd_sc_hd__decap_3
XFILLER_23_155 VPWR VGND VPWR VGND sky130_fd_sc_hd__decap_3
XFILLER_2_6 VPWR VGND VPWR VGND sky130_fd_sc_hd__decap_3
XFILLER_11_33 VPWR VGND VPWR VGND sky130_fd_sc_hd__decap_3
XFILLER_11_66 VPWR VGND VPWR VGND sky130_fd_sc_hd__decap_3
XFILLER_11_99 VPWR VGND VPWR VGND sky130_fd_sc_hd__decap_3
XFILLER_14_100 VPWR VGND VPWR VGND sky130_fd_sc_hd__decap_3
XFILLER_14_133 VPWR VGND VPWR VGND sky130_fd_sc_hd__decap_3
XFILLER_14_144 VPWR VGND VPWR VGND sky130_fd_sc_hd__decap_3
XFILLER_14_177 VPWR VGND VPWR VGND sky130_fd_sc_hd__decap_3
XFILLER_20_103 VPWR VGND VPWR VGND sky130_fd_sc_hd__decap_3
XFILLER_20_136 VPWR VGND VPWR VGND sky130_fd_sc_hd__decap_3
XFILLER_20_147 VPWR VGND VPWR VGND sky130_fd_sc_hd__decap_3
XFILLER_9_181 VPWR VGND VPWR VGND sky130_fd_sc_hd__decap_3
XPHY_EDGE_ROW_5_Left_33 VPWR VGND VPWR VGND sky130_fd_sc_hd__decap_3
XFILLER_11_125 VPWR VGND VPWR VGND sky130_fd_sc_hd__decap_3
XFILLER_11_158 VPWR VGND VPWR VGND sky130_fd_sc_hd__decap_3
XFILLER_11_169 VPWR VGND VPWR VGND sky130_fd_sc_hd__decap_3
XFILLER_22_21 VPWR VGND VPWR VGND sky130_fd_sc_hd__decap_3
XFILLER_22_32 VPWR VGND VPWR VGND sky130_fd_sc_hd__decap_3
XFILLER_22_65 VPWR VGND VPWR VGND sky130_fd_sc_hd__decap_3
XFILLER_0_3 VPWR VGND VPWR VGND sky130_fd_sc_hd__decap_3
XFILLER_8_12 VPWR VGND VPWR VGND sky130_fd_sc_hd__decap_3
XFILLER_8_56 VPWR VGND VPWR VGND sky130_fd_sc_hd__decap_3
XFILLER_6_162 VPWR VGND VPWR VGND sky130_fd_sc_hd__decap_3
XFILLER_10_180 VPWR VGND VPWR VGND sky130_fd_sc_hd__decap_3
XFILLER_17_21 VPWR VGND VPWR VGND sky130_fd_sc_hd__decap_3
XFILLER_17_87 VPWR VGND VPWR VGND sky130_fd_sc_hd__decap_3
XFILLER_3_143 VPWR VGND VPWR VGND sky130_fd_sc_hd__decap_3
XFILLER_3_187 VPWR VGND VPWR VGND sky130_fd_sc_hd__decap_3
XFILLER_0_113 VPWR VGND VPWR VGND sky130_fd_sc_hd__decap_3
XFILLER_5_57 VPWR VGND VPWR VGND sky130_fd_sc_hd__decap_3
XFILLER_5_24 VPWR VGND VPWR VGND sky130_fd_sc_hd__decap_3
XFILLER_14_44 VPWR VGND VPWR VGND sky130_fd_sc_hd__decap_3
XFILLER_14_77 VPWR VGND VPWR VGND sky130_fd_sc_hd__decap_3
XFILLER_14_88 VPWR VGND VPWR VGND sky130_fd_sc_hd__decap_3
XFILLER_27_109 VPWR VGND VPWR VGND sky130_fd_sc_hd__decap_3
XFILLER_18_109 VPWR VGND VPWR VGND sky130_fd_sc_hd__decap_3
XFILLER_26_186 VPWR VGND VPWR VGND sky130_fd_sc_hd__decap_3
XFILLER_26_153 VPWR VGND VPWR VGND sky130_fd_sc_hd__decap_3
XFILLER_25_87 VPWR VGND VPWR VGND sky130_fd_sc_hd__decap_3
XFILLER_25_21 VPWR VGND VPWR VGND sky130_fd_sc_hd__decap_3
XFILLER_2_47 VPWR VGND VPWR VGND sky130_fd_sc_hd__decap_3
XFILLER_17_131 VPWR VGND VPWR VGND sky130_fd_sc_hd__decap_3
XFILLER_17_164 VPWR VGND VPWR VGND sky130_fd_sc_hd__decap_3
XFILLER_17_175 VPWR VGND VPWR VGND sky130_fd_sc_hd__decap_3
XFILLER_23_134 VPWR VGND VPWR VGND sky130_fd_sc_hd__decap_3
XFILLER_23_178 VPWR VGND VPWR VGND sky130_fd_sc_hd__decap_3
XFILLER_11_12 VPWR VGND VPWR VGND sky130_fd_sc_hd__decap_3
XFILLER_11_45 VPWR VGND VPWR VGND sky130_fd_sc_hd__decap_3
XFILLER_11_78 VPWR VGND VPWR VGND sky130_fd_sc_hd__decap_3
XFILLER_14_112 VPWR VGND VPWR VGND sky130_fd_sc_hd__decap_3
XFILLER_14_156 VPWR VGND VPWR VGND sky130_fd_sc_hd__decap_3
XFILLER_20_115 VPWR VGND VPWR VGND sky130_fd_sc_hd__decap_3
XFILLER_20_159 VPWR VGND VPWR VGND sky130_fd_sc_hd__decap_3
XFILLER_3_90 VPWR VGND VPWR VGND sky130_fd_sc_hd__decap_3
XFILLER_11_137 VPWR VGND VPWR VGND sky130_fd_sc_hd__decap_3
XFILLER_7_108 VPWR VGND VPWR VGND sky130_fd_sc_hd__decap_3
XFILLER_7_119 VPWR VGND VPWR VGND sky130_fd_sc_hd__decap_3
XFILLER_22_44 VPWR VGND VPWR VGND sky130_fd_sc_hd__decap_3
XFILLER_22_77 VPWR VGND VPWR VGND sky130_fd_sc_hd__decap_3
XFILLER_22_88 VPWR VGND VPWR VGND sky130_fd_sc_hd__decap_3
XFILLER_8_24 VPWR VGND VPWR VGND sky130_fd_sc_hd__decap_3
XFILLER_8_35 VPWR VGND VPWR VGND sky130_fd_sc_hd__decap_3
XFILLER_8_68 VPWR VGND VPWR VGND sky130_fd_sc_hd__decap_3
XFILLER_6_130 VPWR VGND VPWR VGND sky130_fd_sc_hd__decap_3
XFILLER_6_141 VPWR VGND VPWR VGND sky130_fd_sc_hd__decap_3
XFILLER_6_174 VPWR VGND VPWR VGND sky130_fd_sc_hd__decap_3
XFILLER_26_3 VPWR VGND VPWR VGND sky130_fd_sc_hd__decap_3
XFILLER_17_33 VPWR VGND VPWR VGND sky130_fd_sc_hd__decap_3
XFILLER_17_66 VPWR VGND VPWR VGND sky130_fd_sc_hd__decap_3
XFILLER_17_99 VPWR VGND VPWR VGND sky130_fd_sc_hd__decap_3
XFILLER_3_155 VPWR VGND VPWR VGND sky130_fd_sc_hd__decap_3
XFILLER_3_122 VPWR VGND VPWR VGND sky130_fd_sc_hd__decap_3
XFILLER_12_9 VPWR VGND VPWR VGND sky130_fd_sc_hd__decap_3
XPHY_EDGE_ROW_3_Right_3 VPWR VGND VPWR VGND sky130_fd_sc_hd__decap_3
XFILLER_0_169 VPWR VGND VPWR VGND sky130_fd_sc_hd__decap_3
XFILLER_0_147 VPWR VGND VPWR VGND sky130_fd_sc_hd__decap_3
XFILLER_0_125 VPWR VGND VPWR VGND sky130_fd_sc_hd__decap_3
XFILLER_5_69 VPWR VGND VPWR VGND sky130_fd_sc_hd__decap_3
XFILLER_5_36 VPWR VGND VPWR VGND sky130_fd_sc_hd__decap_3
XFILLER_10_6 VPWR VGND VPWR VGND sky130_fd_sc_hd__decap_3
XFILLER_14_12 VPWR VGND VPWR VGND sky130_fd_sc_hd__decap_3
XFILLER_14_56 VPWR VGND VPWR VGND sky130_fd_sc_hd__decap_3
XFILLER_26_121 VPWR VGND VPWR VGND sky130_fd_sc_hd__decap_3
XFILLER_26_165 VPWR VGND VPWR VGND sky130_fd_sc_hd__decap_3
XFILLER_25_99 VPWR VGND VPWR VGND sky130_fd_sc_hd__decap_3
XFILLER_25_66 VPWR VGND VPWR VGND sky130_fd_sc_hd__decap_3
XFILLER_25_33 VPWR VGND VPWR VGND sky130_fd_sc_hd__decap_3
XFILLER_2_59 VPWR VGND VPWR VGND sky130_fd_sc_hd__decap_3
XFILLER_2_15 VPWR VGND VPWR VGND sky130_fd_sc_hd__decap_3
XFILLER_17_143 VPWR VGND VPWR VGND sky130_fd_sc_hd__decap_3
XFILLER_17_187 VPWR VGND VPWR VGND sky130_fd_sc_hd__decap_3
XFILLER_23_146 VPWR VGND VPWR VGND sky130_fd_sc_hd__decap_3
XFILLER_23_113 VPWR VGND VPWR VGND sky130_fd_sc_hd__decap_3
XFILLER_23_102 VPWR VGND VPWR VGND sky130_fd_sc_hd__decap_3
XFILLER_11_24 VPWR VGND VPWR VGND sky130_fd_sc_hd__decap_3
XFILLER_11_57 VPWR VGND VPWR VGND sky130_fd_sc_hd__decap_3
XFILLER_14_124 VPWR VGND VPWR VGND sky130_fd_sc_hd__decap_3
XFILLER_14_168 VPWR VGND VPWR VGND sky130_fd_sc_hd__decap_3
XFILLER_9_161 VPWR VGND VPWR VGND sky130_fd_sc_hd__decap_3
XFILLER_9_172 VPWR VGND VPWR VGND sky130_fd_sc_hd__decap_3
XFILLER_20_127 VPWR VGND VPWR VGND sky130_fd_sc_hd__decap_3
XFILLER_11_105 VPWR VGND VPWR VGND sky130_fd_sc_hd__decap_3
XFILLER_11_116 VPWR VGND VPWR VGND sky130_fd_sc_hd__decap_3
XFILLER_11_149 VPWR VGND VPWR VGND sky130_fd_sc_hd__decap_3
XFILLER_22_12 VPWR VGND VPWR VGND sky130_fd_sc_hd__decap_3
XFILLER_22_56 VPWR VGND VPWR VGND sky130_fd_sc_hd__decap_3
XFILLER_6_153 VPWR VGND VPWR VGND sky130_fd_sc_hd__decap_3
XFILLER_8_47 VPWR VGND VPWR VGND sky130_fd_sc_hd__decap_3
XFILLER_10_171 VPWR VGND VPWR VGND sky130_fd_sc_hd__decap_3
XFILLER_6_186 VPWR VGND VPWR VGND sky130_fd_sc_hd__decap_3
XFILLER_19_3 VPWR VGND VPWR VGND sky130_fd_sc_hd__decap_3
XFILLER_17_12 VPWR VGND VPWR VGND sky130_fd_sc_hd__decap_3
XFILLER_17_45 VPWR VGND VPWR VGND sky130_fd_sc_hd__decap_3
XFILLER_17_78 VPWR VGND VPWR VGND sky130_fd_sc_hd__decap_3
XFILLER_3_178 VPWR VGND VPWR VGND sky130_fd_sc_hd__decap_3
XFILLER_3_134 VPWR VGND VPWR VGND sky130_fd_sc_hd__decap_3
XFILLER_0_81 VPWR VGND VPWR VGND sky130_fd_sc_hd__decap_3
XFILLER_9_90 VPWR VGND VPWR VGND sky130_fd_sc_hd__decap_3
XFILLER_0_159 VPWR VGND VPWR VGND sky130_fd_sc_hd__decap_3
XFILLER_0_137 VPWR VGND VPWR VGND sky130_fd_sc_hd__decap_3
XFILLER_5_15 VPWR VGND VPWR VGND sky130_fd_sc_hd__decap_3
XFILLER_5_48 VPWR VGND VPWR VGND sky130_fd_sc_hd__decap_3
XPHY_EDGE_ROW_13_Right_13 VPWR VGND VPWR VGND sky130_fd_sc_hd__decap_3
XPHY_EDGE_ROW_22_Right_22 VPWR VGND VPWR VGND sky130_fd_sc_hd__decap_3
XFILLER_14_24 VPWR VGND VPWR VGND sky130_fd_sc_hd__decap_3
XFILLER_14_35 VPWR VGND VPWR VGND sky130_fd_sc_hd__decap_3
XFILLER_14_68 VPWR VGND VPWR VGND sky130_fd_sc_hd__decap_3
XFILLER_6_80 VPWR VGND VPWR VGND sky130_fd_sc_hd__decap_3
XFILLER_6_91 VPWR VGND VPWR VGND sky130_fd_sc_hd__decap_3
XFILLER_26_144 VPWR VGND VPWR VGND sky130_fd_sc_hd__decap_3
XFILLER_26_133 VPWR VGND VPWR VGND sky130_fd_sc_hd__decap_3
XFILLER_26_100 VPWR VGND VPWR VGND sky130_fd_sc_hd__decap_3
XFILLER_25_12 VPWR VGND VPWR VGND sky130_fd_sc_hd__decap_3
XFILLER_26_177 VPWR VGND VPWR VGND sky130_fd_sc_hd__decap_3
XFILLER_25_78 VPWR VGND VPWR VGND sky130_fd_sc_hd__decap_3
XFILLER_25_45 VPWR VGND VPWR VGND sky130_fd_sc_hd__decap_3
XFILLER_2_38 VPWR VGND VPWR VGND sky130_fd_sc_hd__decap_3
XFILLER_17_122 VPWR VGND VPWR VGND sky130_fd_sc_hd__decap_3
XFILLER_17_155 VPWR VGND VPWR VGND sky130_fd_sc_hd__decap_3
XFILLER_23_169 VPWR VGND VPWR VGND sky130_fd_sc_hd__decap_3
XFILLER_23_158 VPWR VGND VPWR VGND sky130_fd_sc_hd__decap_3
XFILLER_23_125 VPWR VGND VPWR VGND sky130_fd_sc_hd__decap_3
XFILLER_11_36 VPWR VGND VPWR VGND sky130_fd_sc_hd__decap_3
XFILLER_11_69 VPWR VGND VPWR VGND sky130_fd_sc_hd__decap_3
XFILLER_2_9 VPWR VGND VPWR VGND sky130_fd_sc_hd__decap_3
XFILLER_14_103 VPWR VGND VPWR VGND sky130_fd_sc_hd__decap_3
XFILLER_14_136 VPWR VGND VPWR VGND sky130_fd_sc_hd__decap_3
XFILLER_22_180 VPWR VGND VPWR VGND sky130_fd_sc_hd__decap_3
XFILLER_14_147 VPWR VGND VPWR VGND sky130_fd_sc_hd__decap_3
XFILLER_20_106 VPWR VGND VPWR VGND sky130_fd_sc_hd__decap_3
XFILLER_9_140 VPWR VGND VPWR VGND sky130_fd_sc_hd__decap_3
XFILLER_9_184 VPWR VGND VPWR VGND sky130_fd_sc_hd__decap_3
XFILLER_3_81 VPWR VGND VPWR VGND sky130_fd_sc_hd__decap_3
XFILLER_11_128 VPWR VGND VPWR VGND sky130_fd_sc_hd__decap_3
XFILLER_22_24 VPWR VGND VPWR VGND sky130_fd_sc_hd__decap_3
XFILLER_22_35 VPWR VGND VPWR VGND sky130_fd_sc_hd__decap_3
XFILLER_0_6 VPWR VGND VPWR VGND sky130_fd_sc_hd__decap_3
XFILLER_22_68 VPWR VGND VPWR VGND sky130_fd_sc_hd__decap_3
XFILLER_8_15 VPWR VGND VPWR VGND sky130_fd_sc_hd__decap_3
XFILLER_6_121 VPWR VGND VPWR VGND sky130_fd_sc_hd__decap_3
XFILLER_6_165 VPWR VGND VPWR VGND sky130_fd_sc_hd__decap_3
XFILLER_8_59 VPWR VGND VPWR VGND sky130_fd_sc_hd__decap_3
XFILLER_10_150 VPWR VGND VPWR VGND sky130_fd_sc_hd__decap_3
XFILLER_10_183 VPWR VGND VPWR VGND sky130_fd_sc_hd__decap_3
XPHY_EDGE_ROW_9_Left_37 VPWR VGND VPWR VGND sky130_fd_sc_hd__decap_3
XFILLER_17_24 VPWR VGND VPWR VGND sky130_fd_sc_hd__decap_3
XFILLER_17_57 VPWR VGND VPWR VGND sky130_fd_sc_hd__decap_3
XFILLER_3_102 VPWR VGND VPWR VGND sky130_fd_sc_hd__decap_3
XFILLER_3_146 VPWR VGND VPWR VGND sky130_fd_sc_hd__decap_3
XFILLER_3_113 VPWR VGND VPWR VGND sky130_fd_sc_hd__decap_3
XFILLER_0_60 VPWR VGND VPWR VGND sky130_fd_sc_hd__decap_3
XFILLER_0_116 VPWR VGND VPWR VGND sky130_fd_sc_hd__decap_3
XFILLER_5_27 VPWR VGND VPWR VGND sky130_fd_sc_hd__decap_3
XFILLER_14_47 VPWR VGND VPWR VGND sky130_fd_sc_hd__decap_3
XFILLER_26_156 VPWR VGND VPWR VGND sky130_fd_sc_hd__decap_3
XFILLER_26_112 VPWR VGND VPWR VGND sky130_fd_sc_hd__decap_3
XFILLER_25_24 VPWR VGND VPWR VGND sky130_fd_sc_hd__decap_3
XFILLER_25_57 VPWR VGND VPWR VGND sky130_fd_sc_hd__decap_3
XFILLER_9_3 VPWR VGND VPWR VGND sky130_fd_sc_hd__decap_3
XFILLER_17_134 VPWR VGND VPWR VGND sky130_fd_sc_hd__decap_3
XFILLER_17_178 VPWR VGND VPWR VGND sky130_fd_sc_hd__decap_3
XFILLER_15_90 VPWR VGND VPWR VGND sky130_fd_sc_hd__decap_3
XFILLER_23_137 VPWR VGND VPWR VGND sky130_fd_sc_hd__decap_3
XFILLER_11_15 VPWR VGND VPWR VGND sky130_fd_sc_hd__decap_3
XFILLER_11_48 VPWR VGND VPWR VGND sky130_fd_sc_hd__decap_3
XFILLER_14_115 VPWR VGND VPWR VGND sky130_fd_sc_hd__decap_3
XFILLER_14_159 VPWR VGND VPWR VGND sky130_fd_sc_hd__decap_3
XFILLER_9_152 VPWR VGND VPWR VGND sky130_fd_sc_hd__decap_3
XFILLER_13_181 VPWR VGND VPWR VGND sky130_fd_sc_hd__decap_3
XFILLER_20_118 VPWR VGND VPWR VGND sky130_fd_sc_hd__decap_3
XFILLER_3_93 VPWR VGND VPWR VGND sky130_fd_sc_hd__decap_3
XFILLER_3_60 VPWR VGND VPWR VGND sky130_fd_sc_hd__decap_3
XFILLER_22_47 VPWR VGND VPWR VGND sky130_fd_sc_hd__decap_3
XFILLER_8_38 VPWR VGND VPWR VGND sky130_fd_sc_hd__decap_3
XFILLER_6_100 VPWR VGND VPWR VGND sky130_fd_sc_hd__decap_3
XFILLER_6_133 VPWR VGND VPWR VGND sky130_fd_sc_hd__decap_3
XFILLER_6_144 VPWR VGND VPWR VGND sky130_fd_sc_hd__decap_3
XFILLER_6_177 VPWR VGND VPWR VGND sky130_fd_sc_hd__decap_3
XFILLER_10_162 VPWR VGND VPWR VGND sky130_fd_sc_hd__decap_3
XFILLER_12_80 VPWR VGND VPWR VGND sky130_fd_sc_hd__decap_3
XFILLER_12_91 VPWR VGND VPWR VGND sky130_fd_sc_hd__decap_3
XFILLER_26_6 VPWR VGND VPWR VGND sky130_fd_sc_hd__decap_3
XPHY_EDGE_ROW_25_Left_53 VPWR VGND VPWR VGND sky130_fd_sc_hd__decap_3
XFILLER_17_36 VPWR VGND VPWR VGND sky130_fd_sc_hd__decap_3
XFILLER_17_69 VPWR VGND VPWR VGND sky130_fd_sc_hd__decap_3
XFILLER_3_125 VPWR VGND VPWR VGND sky130_fd_sc_hd__decap_3
XFILLER_3_169 VPWR VGND VPWR VGND sky130_fd_sc_hd__decap_3
XFILLER_3_158 VPWR VGND VPWR VGND sky130_fd_sc_hd__decap_3
XFILLER_23_90 VPWR VGND VPWR VGND sky130_fd_sc_hd__decap_3
XFILLER_24_3 VPWR VGND VPWR VGND sky130_fd_sc_hd__decap_3
XFILLER_2_180 VPWR VGND VPWR VGND sky130_fd_sc_hd__decap_3
XFILLER_0_50 VPWR VGND VPWR VGND sky130_fd_sc_hd__decap_3
XFILLER_0_72 VPWR VGND VPWR VGND sky130_fd_sc_hd__decap_3
XFILLER_9_81 VPWR VGND VPWR VGND sky130_fd_sc_hd__decap_3
XFILLER_0_128 VPWR VGND VPWR VGND sky130_fd_sc_hd__decap_3
XFILLER_5_39 VPWR VGND VPWR VGND sky130_fd_sc_hd__decap_3
XFILLER_10_9 VPWR VGND VPWR VGND sky130_fd_sc_hd__decap_3
XPHY_EDGE_ROW_7_Right_7 VPWR VGND VPWR VGND sky130_fd_sc_hd__decap_3
XPHY_EDGE_ROW_12_Left_40 VPWR VGND VPWR VGND sky130_fd_sc_hd__decap_3
XFILLER_14_15 VPWR VGND VPWR VGND sky130_fd_sc_hd__decap_3
XFILLER_14_59 VPWR VGND VPWR VGND sky130_fd_sc_hd__decap_3
XFILLER_20_80 VPWR VGND VPWR VGND sky130_fd_sc_hd__decap_3
XFILLER_20_91 VPWR VGND VPWR VGND sky130_fd_sc_hd__decap_3
XFILLER_6_71 VPWR VGND VPWR VGND sky130_fd_sc_hd__decap_3
XFILLER_26_168 VPWR VGND VPWR VGND sky130_fd_sc_hd__decap_3
XFILLER_26_124 VPWR VGND VPWR VGND sky130_fd_sc_hd__decap_3
XFILLER_25_69 VPWR VGND VPWR VGND sky130_fd_sc_hd__decap_3
XFILLER_25_36 VPWR VGND VPWR VGND sky130_fd_sc_hd__decap_3
XFILLER_2_29 VPWR VGND VPWR VGND sky130_fd_sc_hd__decap_3
XFILLER_2_18 VPWR VGND VPWR VGND sky130_fd_sc_hd__decap_3
XFILLER_17_102 VPWR VGND VPWR VGND sky130_fd_sc_hd__decap_3
XFILLER_17_113 VPWR VGND VPWR VGND sky130_fd_sc_hd__decap_3
XFILLER_17_146 VPWR VGND VPWR VGND sky130_fd_sc_hd__decap_3
XFILLER_23_116 VPWR VGND VPWR VGND sky130_fd_sc_hd__decap_3
XFILLER_23_105 VPWR VGND VPWR VGND sky130_fd_sc_hd__decap_3
XFILLER_23_149 VPWR VGND VPWR VGND sky130_fd_sc_hd__decap_3
XFILLER_11_27 VPWR VGND VPWR VGND sky130_fd_sc_hd__decap_3
XFILLER_14_127 VPWR VGND VPWR VGND sky130_fd_sc_hd__decap_3
XFILLER_22_171 VPWR VGND VPWR VGND sky130_fd_sc_hd__decap_3
XFILLER_9_131 VPWR VGND VPWR VGND sky130_fd_sc_hd__decap_3
XFILLER_9_164 VPWR VGND VPWR VGND sky130_fd_sc_hd__decap_3
XFILLER_9_175 VPWR VGND VPWR VGND sky130_fd_sc_hd__decap_3
XFILLER_3_72 VPWR VGND VPWR VGND sky130_fd_sc_hd__decap_3
XFILLER_11_108 VPWR VGND VPWR VGND sky130_fd_sc_hd__decap_3
XFILLER_11_119 VPWR VGND VPWR VGND sky130_fd_sc_hd__decap_3
XFILLER_22_15 VPWR VGND VPWR VGND sky130_fd_sc_hd__decap_3
XFILLER_22_59 VPWR VGND VPWR VGND sky130_fd_sc_hd__decap_3
XFILLER_10_130 VPWR VGND VPWR VGND sky130_fd_sc_hd__decap_3
XFILLER_10_141 VPWR VGND VPWR VGND sky130_fd_sc_hd__decap_3
XFILLER_6_112 VPWR VGND VPWR VGND sky130_fd_sc_hd__decap_3
XFILLER_6_156 VPWR VGND VPWR VGND sky130_fd_sc_hd__decap_3
XFILLER_10_174 VPWR VGND VPWR VGND sky130_fd_sc_hd__decap_3
XFILLER_19_6 VPWR VGND VPWR VGND sky130_fd_sc_hd__decap_3
XFILLER_17_15 VPWR VGND VPWR VGND sky130_fd_sc_hd__decap_3
XFILLER_17_48 VPWR VGND VPWR VGND sky130_fd_sc_hd__decap_3
XFILLER_3_137 VPWR VGND VPWR VGND sky130_fd_sc_hd__decap_3
XFILLER_17_3 VPWR VGND VPWR VGND sky130_fd_sc_hd__decap_3
XFILLER_9_60 VPWR VGND VPWR VGND sky130_fd_sc_hd__decap_3
XFILLER_9_93 VPWR VGND VPWR VGND sky130_fd_sc_hd__decap_3
XFILLER_0_107 VPWR VGND VPWR VGND sky130_fd_sc_hd__decap_3
XFILLER_5_18 VPWR VGND VPWR VGND sky130_fd_sc_hd__decap_3
XFILLER_18_80 VPWR VGND VPWR VGND sky130_fd_sc_hd__decap_3
XFILLER_18_91 VPWR VGND VPWR VGND sky130_fd_sc_hd__decap_3
XFILLER_14_38 VPWR VGND VPWR VGND sky130_fd_sc_hd__decap_3
XFILLER_6_50 VPWR VGND VPWR VGND sky130_fd_sc_hd__decap_3
XFILLER_6_94 VPWR VGND VPWR VGND sky130_fd_sc_hd__decap_3
XFILLER_26_103 VPWR VGND VPWR VGND sky130_fd_sc_hd__decap_3
XFILLER_26_147 VPWR VGND VPWR VGND sky130_fd_sc_hd__decap_3
XFILLER_26_136 VPWR VGND VPWR VGND sky130_fd_sc_hd__decap_3
XFILLER_25_48 VPWR VGND VPWR VGND sky130_fd_sc_hd__decap_3
XFILLER_25_15 VPWR VGND VPWR VGND sky130_fd_sc_hd__decap_3
XFILLER_17_125 VPWR VGND VPWR VGND sky130_fd_sc_hd__decap_3
XFILLER_17_158 VPWR VGND VPWR VGND sky130_fd_sc_hd__decap_3
XFILLER_17_169 VPWR VGND VPWR VGND sky130_fd_sc_hd__decap_3
XFILLER_15_81 VPWR VGND VPWR VGND sky130_fd_sc_hd__decap_3
XFILLER_23_128 VPWR VGND VPWR VGND sky130_fd_sc_hd__decap_3
XFILLER_16_180 VPWR VGND VPWR VGND sky130_fd_sc_hd__decap_3
XFILLER_11_39 VPWR VGND VPWR VGND sky130_fd_sc_hd__decap_3
XFILLER_22_183 VPWR VGND VPWR VGND sky130_fd_sc_hd__decap_3
XFILLER_22_150 VPWR VGND VPWR VGND sky130_fd_sc_hd__decap_3
XFILLER_14_106 VPWR VGND VPWR VGND sky130_fd_sc_hd__decap_3
XFILLER_26_91 VPWR VGND VPWR VGND sky130_fd_sc_hd__decap_3
XFILLER_26_80 VPWR VGND VPWR VGND sky130_fd_sc_hd__decap_3
XFILLER_9_143 VPWR VGND VPWR VGND sky130_fd_sc_hd__decap_3
XFILLER_9_187 VPWR VGND VPWR VGND sky130_fd_sc_hd__decap_3
XFILLER_13_161 VPWR VGND VPWR VGND sky130_fd_sc_hd__decap_3
XFILLER_13_172 VPWR VGND VPWR VGND sky130_fd_sc_hd__decap_3
XFILLER_20_109 VPWR VGND VPWR VGND sky130_fd_sc_hd__decap_3
XFILLER_3_84 VPWR VGND VPWR VGND sky130_fd_sc_hd__decap_3
XFILLER_3_51 VPWR VGND VPWR VGND sky130_fd_sc_hd__decap_3
XFILLER_22_38 VPWR VGND VPWR VGND sky130_fd_sc_hd__decap_3
XFILLER_0_9 VPWR VGND VPWR VGND sky130_fd_sc_hd__decap_3
XFILLER_6_124 VPWR VGND VPWR VGND sky130_fd_sc_hd__decap_3
XFILLER_8_18 VPWR VGND VPWR VGND sky130_fd_sc_hd__decap_3
XFILLER_8_29 VPWR VGND VPWR VGND sky130_fd_sc_hd__decap_3
XFILLER_10_153 VPWR VGND VPWR VGND sky130_fd_sc_hd__decap_3
XFILLER_10_186 VPWR VGND VPWR VGND sky130_fd_sc_hd__decap_3
XFILLER_6_168 VPWR VGND VPWR VGND sky130_fd_sc_hd__decap_3
XFILLER_12_71 VPWR VGND VPWR VGND sky130_fd_sc_hd__decap_3
XFILLER_17_27 VPWR VGND VPWR VGND sky130_fd_sc_hd__decap_3
XFILLER_3_149 VPWR VGND VPWR VGND sky130_fd_sc_hd__decap_3
XFILLER_3_116 VPWR VGND VPWR VGND sky130_fd_sc_hd__decap_3
XFILLER_3_105 VPWR VGND VPWR VGND sky130_fd_sc_hd__decap_3
XFILLER_23_81 VPWR VGND VPWR VGND sky130_fd_sc_hd__decap_3
XFILLER_2_171 VPWR VGND VPWR VGND sky130_fd_sc_hd__decap_3
XFILLER_0_41 VPWR VGND VPWR VGND sky130_fd_sc_hd__decap_3
XFILLER_0_63 VPWR VGND VPWR VGND sky130_fd_sc_hd__decap_3
XFILLER_0_85 VPWR VGND VPWR VGND sky130_fd_sc_hd__decap_3
XFILLER_9_72 VPWR VGND VPWR VGND sky130_fd_sc_hd__decap_3
XFILLER_0_119 VPWR VGND VPWR VGND sky130_fd_sc_hd__decap_3
XFILLER_20_71 VPWR VGND VPWR VGND sky130_fd_sc_hd__decap_3
XFILLER_6_62 VPWR VGND VPWR VGND sky130_fd_sc_hd__decap_3
XFILLER_26_115 VPWR VGND VPWR VGND sky130_fd_sc_hd__decap_3
XFILLER_26_159 VPWR VGND VPWR VGND sky130_fd_sc_hd__decap_3
XFILLER_25_27 VPWR VGND VPWR VGND sky130_fd_sc_hd__decap_3
XFILLER_9_6 VPWR VGND VPWR VGND sky130_fd_sc_hd__decap_3
XFILLER_17_137 VPWR VGND VPWR VGND sky130_fd_sc_hd__decap_3
XFILLER_25_181 VPWR VGND VPWR VGND sky130_fd_sc_hd__decap_3
XFILLER_15_60 VPWR VGND VPWR VGND sky130_fd_sc_hd__decap_3
XFILLER_15_93 VPWR VGND VPWR VGND sky130_fd_sc_hd__decap_3
Xoutput2 VGND VPWR VPWR VGND u_buf/X ro_out output2/a_244_47# output2/a_355_47# output2/a_27_47#
+ sky130_fd_sc_hd__clkdlybuf4s25_1
XFILLER_11_18 VPWR VGND VPWR VGND sky130_fd_sc_hd__decap_3
XFILLER_14_118 VPWR VGND VPWR VGND sky130_fd_sc_hd__decap_3
XFILLER_22_162 VPWR VGND VPWR VGND sky130_fd_sc_hd__decap_3
XFILLER_7_3 VPWR VGND VPWR VGND sky130_fd_sc_hd__decap_3
XFILLER_13_140 VPWR VGND VPWR VGND sky130_fd_sc_hd__decap_3
XFILLER_9_122 VPWR VGND VPWR VGND sky130_fd_sc_hd__decap_3
XFILLER_9_155 VPWR VGND VPWR VGND sky130_fd_sc_hd__decap_3
XFILLER_13_184 VPWR VGND VPWR VGND sky130_fd_sc_hd__decap_3
XFILLER_3_63 VPWR VGND VPWR VGND sky130_fd_sc_hd__decap_3
XFILLER_3_30 VPWR VGND VPWR VGND sky130_fd_sc_hd__decap_3
XFILLER_3_96 VPWR VGND VPWR VGND sky130_fd_sc_hd__decap_3
XFILLER_6_103 VPWR VGND VPWR VGND sky130_fd_sc_hd__decap_3
XFILLER_6_136 VPWR VGND VPWR VGND sky130_fd_sc_hd__decap_3
XFILLER_6_147 VPWR VGND VPWR VGND sky130_fd_sc_hd__decap_3
XFILLER_10_121 VPWR VGND VPWR VGND sky130_fd_sc_hd__decap_3
XFILLER_10_165 VPWR VGND VPWR VGND sky130_fd_sc_hd__decap_3
XFILLER_12_50 VPWR VGND VPWR VGND sky130_fd_sc_hd__decap_3
XFILLER_12_94 VPWR VGND VPWR VGND sky130_fd_sc_hd__decap_3
XFILLER_26_9 VPWR VGND VPWR VGND sky130_fd_sc_hd__decap_3
XFILLER_17_39 VPWR VGND VPWR VGND sky130_fd_sc_hd__decap_3
XFILLER_3_128 VPWR VGND VPWR VGND sky130_fd_sc_hd__decap_3
XFILLER_23_93 VPWR VGND VPWR VGND sky130_fd_sc_hd__decap_3
XFILLER_23_60 VPWR VGND VPWR VGND sky130_fd_sc_hd__decap_3
XFILLER_24_6 VPWR VGND VPWR VGND sky130_fd_sc_hd__decap_3
XFILLER_2_183 VPWR VGND VPWR VGND sky130_fd_sc_hd__decap_3
XFILLER_2_150 VPWR VGND VPWR VGND sky130_fd_sc_hd__decap_3
XFILLER_0_53 VPWR VGND VPWR VGND sky130_fd_sc_hd__decap_3
XFILLER_0_75 VPWR VGND VPWR VGND sky130_fd_sc_hd__decap_3
XFILLER_9_51 VPWR VGND VPWR VGND sky130_fd_sc_hd__decap_3
XFILLER_9_84 VPWR VGND VPWR VGND sky130_fd_sc_hd__decap_3
XFILLER_18_71 VPWR VGND VPWR VGND sky130_fd_sc_hd__decap_3
XFILLER_22_3 VPWR VGND VPWR VGND sky130_fd_sc_hd__decap_3
XFILLER_14_18 VPWR VGND VPWR VGND sky130_fd_sc_hd__decap_3
XFILLER_14_29 VPWR VGND VPWR VGND sky130_fd_sc_hd__decap_3
XFILLER_20_50 VPWR VGND VPWR VGND sky130_fd_sc_hd__decap_3
XFILLER_20_94 VPWR VGND VPWR VGND sky130_fd_sc_hd__decap_3
XFILLER_6_41 VPWR VGND VPWR VGND sky130_fd_sc_hd__decap_3
XFILLER_6_74 VPWR VGND VPWR VGND sky130_fd_sc_hd__decap_3
XFILLER_6_85 VPWR VGND VPWR VGND sky130_fd_sc_hd__decap_3
XFILLER_26_127 VPWR VGND VPWR VGND sky130_fd_sc_hd__decap_3
XPHY_EDGE_ROW_16_Left_44 VPWR VGND VPWR VGND sky130_fd_sc_hd__decap_3
XFILLER_25_39 VPWR VGND VPWR VGND sky130_fd_sc_hd__decap_3
XFILLER_17_105 VPWR VGND VPWR VGND sky130_fd_sc_hd__decap_3
XFILLER_17_116 VPWR VGND VPWR VGND sky130_fd_sc_hd__decap_3
XFILLER_17_149 VPWR VGND VPWR VGND sky130_fd_sc_hd__decap_3
XFILLER_15_72 VPWR VGND VPWR VGND sky130_fd_sc_hd__decap_3
XFILLER_23_119 VPWR VGND VPWR VGND sky130_fd_sc_hd__decap_3
XFILLER_23_108 VPWR VGND VPWR VGND sky130_fd_sc_hd__decap_3
XFILLER_16_171 VPWR VGND VPWR VGND sky130_fd_sc_hd__decap_3
XPHY_EDGE_ROW_1_Left_29 VPWR VGND VPWR VGND sky130_fd_sc_hd__decap_3
XFILLER_22_174 VPWR VGND VPWR VGND sky130_fd_sc_hd__decap_3
XFILLER_22_141 VPWR VGND VPWR VGND sky130_fd_sc_hd__decap_3
XFILLER_22_130 VPWR VGND VPWR VGND sky130_fd_sc_hd__decap_3
XFILLER_26_71 VPWR VGND VPWR VGND sky130_fd_sc_hd__decap_3
XFILLER_9_134 VPWR VGND VPWR VGND sky130_fd_sc_hd__decap_3
XFILLER_13_152 VPWR VGND VPWR VGND sky130_fd_sc_hd__decap_3
XFILLER_9_178 VPWR VGND VPWR VGND sky130_fd_sc_hd__decap_3
XFILLER_3_75 VPWR VGND VPWR VGND sky130_fd_sc_hd__decap_3
XFILLER_3_42 VPWR VGND VPWR VGND sky130_fd_sc_hd__decap_3
XFILLER_22_18 VPWR VGND VPWR VGND sky130_fd_sc_hd__decap_3
XFILLER_22_29 VPWR VGND VPWR VGND sky130_fd_sc_hd__decap_3
XFILLER_10_100 VPWR VGND VPWR VGND sky130_fd_sc_hd__decap_3
XFILLER_6_115 VPWR VGND VPWR VGND sky130_fd_sc_hd__decap_3
XFILLER_6_159 VPWR VGND VPWR VGND sky130_fd_sc_hd__decap_3
XFILLER_10_133 VPWR VGND VPWR VGND sky130_fd_sc_hd__decap_3
XFILLER_10_144 VPWR VGND VPWR VGND sky130_fd_sc_hd__decap_3
XFILLER_10_177 VPWR VGND VPWR VGND sky130_fd_sc_hd__decap_3
XFILLER_12_62 VPWR VGND VPWR VGND sky130_fd_sc_hd__decap_3
XFILLER_19_9 VPWR VGND VPWR VGND sky130_fd_sc_hd__decap_3
XFILLER_5_181 VPWR VGND VPWR VGND sky130_fd_sc_hd__decap_3
XFILLER_17_18 VPWR VGND VPWR VGND sky130_fd_sc_hd__decap_3
XFILLER_23_72 VPWR VGND VPWR VGND sky130_fd_sc_hd__decap_3
XPHY_EDGE_ROW_4_Left_32 VPWR VGND VPWR VGND sky130_fd_sc_hd__decap_3
XFILLER_2_162 VPWR VGND VPWR VGND sky130_fd_sc_hd__decap_3
XFILLER_17_6 VPWR VGND VPWR VGND sky130_fd_sc_hd__decap_3
XFILLER_0_21 VPWR VGND VPWR VGND sky130_fd_sc_hd__decap_3
XFILLER_0_32 VPWR VGND VPWR VGND sky130_fd_sc_hd__decap_3
XFILLER_9_30 VPWR VGND VPWR VGND sky130_fd_sc_hd__decap_3
XFILLER_9_63 VPWR VGND VPWR VGND sky130_fd_sc_hd__decap_3
XFILLER_9_96 VPWR VGND VPWR VGND sky130_fd_sc_hd__decap_3
XFILLER_18_50 VPWR VGND VPWR VGND sky130_fd_sc_hd__decap_3
XFILLER_18_94 VPWR VGND VPWR VGND sky130_fd_sc_hd__decap_3
XFILLER_15_3 VPWR VGND VPWR VGND sky130_fd_sc_hd__decap_3
XFILLER_20_62 VPWR VGND VPWR VGND sky130_fd_sc_hd__decap_3
XFILLER_6_53 VPWR VGND VPWR VGND sky130_fd_sc_hd__decap_3
XFILLER_6_97 VPWR VGND VPWR VGND sky130_fd_sc_hd__decap_3
XFILLER_26_106 VPWR VGND VPWR VGND sky130_fd_sc_hd__decap_3
XFILLER_25_18 VPWR VGND VPWR VGND sky130_fd_sc_hd__decap_3
XFILLER_25_172 VPWR VGND VPWR VGND sky130_fd_sc_hd__decap_3
XFILLER_25_161 VPWR VGND VPWR VGND sky130_fd_sc_hd__decap_3
XFILLER_15_51 VPWR VGND VPWR VGND sky130_fd_sc_hd__decap_3
XFILLER_15_84 VPWR VGND VPWR VGND sky130_fd_sc_hd__decap_3
XFILLER_17_128 VPWR VGND VPWR VGND sky130_fd_sc_hd__decap_3
XFILLER_16_150 VPWR VGND VPWR VGND sky130_fd_sc_hd__decap_3
XFILLER_16_183 VPWR VGND VPWR VGND sky130_fd_sc_hd__decap_3
XFILLER_14_109 VPWR VGND VPWR VGND sky130_fd_sc_hd__decap_3
XFILLER_22_186 VPWR VGND VPWR VGND sky130_fd_sc_hd__decap_3
XFILLER_22_153 VPWR VGND VPWR VGND sky130_fd_sc_hd__decap_3
XFILLER_26_50 VPWR VGND VPWR VGND sky130_fd_sc_hd__decap_3
XFILLER_26_94 VPWR VGND VPWR VGND sky130_fd_sc_hd__decap_3
XFILLER_9_102 VPWR VGND VPWR VGND sky130_fd_sc_hd__decap_3
XFILLER_9_113 VPWR VGND VPWR VGND sky130_fd_sc_hd__decap_3
XFILLER_9_146 VPWR VGND VPWR VGND sky130_fd_sc_hd__decap_3
XFILLER_13_131 VPWR VGND VPWR VGND sky130_fd_sc_hd__decap_3
XFILLER_13_164 VPWR VGND VPWR VGND sky130_fd_sc_hd__decap_3
XFILLER_13_175 VPWR VGND VPWR VGND sky130_fd_sc_hd__decap_3
XFILLER_3_87 VPWR VGND VPWR VGND sky130_fd_sc_hd__decap_3
XFILLER_3_21 VPWR VGND VPWR VGND sky130_fd_sc_hd__decap_3
XFILLER_10_112 VPWR VGND VPWR VGND sky130_fd_sc_hd__decap_3
XFILLER_6_127 VPWR VGND VPWR VGND sky130_fd_sc_hd__decap_3
XFILLER_10_156 VPWR VGND VPWR VGND sky130_fd_sc_hd__decap_3
XFILLER_12_41 VPWR VGND VPWR VGND sky130_fd_sc_hd__decap_3
XFILLER_12_74 VPWR VGND VPWR VGND sky130_fd_sc_hd__decap_3
XFILLER_12_85 VPWR VGND VPWR VGND sky130_fd_sc_hd__decap_3
XPHY_EDGE_ROW_16_Right_16 VPWR VGND VPWR VGND sky130_fd_sc_hd__decap_3
XPHY_EDGE_ROW_25_Right_25 VPWR VGND VPWR VGND sky130_fd_sc_hd__decap_3
XFILLER_3_119 VPWR VGND VPWR VGND sky130_fd_sc_hd__decap_3
XFILLER_3_108 VPWR VGND VPWR VGND sky130_fd_sc_hd__decap_3
XFILLER_23_84 VPWR VGND VPWR VGND sky130_fd_sc_hd__decap_3
XFILLER_23_51 VPWR VGND VPWR VGND sky130_fd_sc_hd__decap_3
XFILLER_2_174 VPWR VGND VPWR VGND sky130_fd_sc_hd__decap_3
XFILLER_2_141 VPWR VGND VPWR VGND sky130_fd_sc_hd__decap_3
XFILLER_0_44 VPWR VGND VPWR VGND sky130_fd_sc_hd__decap_3
XFILLER_0_66 VPWR VGND VPWR VGND sky130_fd_sc_hd__decap_3
XFILLER_0_88 VPWR VGND VPWR VGND sky130_fd_sc_hd__decap_3
XFILLER_9_42 VPWR VGND VPWR VGND sky130_fd_sc_hd__decap_3
XFILLER_9_75 VPWR VGND VPWR VGND sky130_fd_sc_hd__decap_3
XFILLER_18_62 VPWR VGND VPWR VGND sky130_fd_sc_hd__decap_3
XPHY_EDGE_ROW_2_Right_2 VPWR VGND VPWR VGND sky130_fd_sc_hd__decap_3
XFILLER_20_41 VPWR VGND VPWR VGND sky130_fd_sc_hd__decap_3
XFILLER_20_74 VPWR VGND VPWR VGND sky130_fd_sc_hd__decap_3
XFILLER_20_85 VPWR VGND VPWR VGND sky130_fd_sc_hd__decap_3
XFILLER_6_21 VPWR VGND VPWR VGND sky130_fd_sc_hd__decap_3
XFILLER_6_32 VPWR VGND VPWR VGND sky130_fd_sc_hd__decap_3
XFILLER_6_65 VPWR VGND VPWR VGND sky130_fd_sc_hd__decap_3
XFILLER_26_118 VPWR VGND VPWR VGND sky130_fd_sc_hd__decap_3
XFILLER_19_181 VPWR VGND VPWR VGND sky130_fd_sc_hd__decap_3
XFILLER_9_9 VPWR VGND VPWR VGND sky130_fd_sc_hd__decap_3
XFILLER_25_184 VPWR VGND VPWR VGND sky130_fd_sc_hd__decap_3
XFILLER_25_140 VPWR VGND VPWR VGND sky130_fd_sc_hd__decap_3
XFILLER_15_30 VPWR VGND VPWR VGND sky130_fd_sc_hd__decap_3
XFILLER_15_63 VPWR VGND VPWR VGND sky130_fd_sc_hd__decap_3
XFILLER_15_96 VPWR VGND VPWR VGND sky130_fd_sc_hd__decap_3
XFILLER_16_162 VPWR VGND VPWR VGND sky130_fd_sc_hd__decap_3
XFILLER_22_165 VPWR VGND VPWR VGND sky130_fd_sc_hd__decap_3
XFILLER_22_121 VPWR VGND VPWR VGND sky130_fd_sc_hd__decap_3
XFILLER_7_6 VPWR VGND VPWR VGND sky130_fd_sc_hd__decap_3
XFILLER_26_62 VPWR VGND VPWR VGND sky130_fd_sc_hd__decap_3
XFILLER_9_125 VPWR VGND VPWR VGND sky130_fd_sc_hd__decap_3
XFILLER_9_158 VPWR VGND VPWR VGND sky130_fd_sc_hd__decap_3
XFILLER_9_169 VPWR VGND VPWR VGND sky130_fd_sc_hd__decap_3
XFILLER_13_143 VPWR VGND VPWR VGND sky130_fd_sc_hd__decap_3
XFILLER_13_187 VPWR VGND VPWR VGND sky130_fd_sc_hd__decap_3
XFILLER_3_99 VPWR VGND VPWR VGND sky130_fd_sc_hd__decap_3
XFILLER_3_66 VPWR VGND VPWR VGND sky130_fd_sc_hd__decap_3
XFILLER_3_33 VPWR VGND VPWR VGND sky130_fd_sc_hd__decap_3
XFILLER_8_180 VPWR VGND VPWR VGND sky130_fd_sc_hd__decap_3
XFILLER_6_106 VPWR VGND VPWR VGND sky130_fd_sc_hd__decap_3
XFILLER_10_124 VPWR VGND VPWR VGND sky130_fd_sc_hd__decap_3
XFILLER_10_168 VPWR VGND VPWR VGND sky130_fd_sc_hd__decap_3
XFILLER_5_3 VPWR VGND VPWR VGND sky130_fd_sc_hd__decap_3
XFILLER_12_53 VPWR VGND VPWR VGND sky130_fd_sc_hd__decap_3
XFILLER_12_97 VPWR VGND VPWR VGND sky130_fd_sc_hd__decap_3
XFILLER_5_161 VPWR VGND VPWR VGND sky130_fd_sc_hd__decap_3
XFILLER_5_172 VPWR VGND VPWR VGND sky130_fd_sc_hd__decap_3
XFILLER_23_96 VPWR VGND VPWR VGND sky130_fd_sc_hd__decap_3
XFILLER_23_63 VPWR VGND VPWR VGND sky130_fd_sc_hd__decap_3
XFILLER_23_30 VPWR VGND VPWR VGND sky130_fd_sc_hd__decap_3
XFILLER_2_186 VPWR VGND VPWR VGND sky130_fd_sc_hd__decap_3
XFILLER_2_153 VPWR VGND VPWR VGND sky130_fd_sc_hd__decap_3
XFILLER_2_131 VPWR VGND VPWR VGND sky130_fd_sc_hd__decap_3
XFILLER_24_9 VPWR VGND VPWR VGND sky130_fd_sc_hd__decap_3
XFILLER_0_12 VPWR VGND VPWR VGND sky130_fd_sc_hd__decap_3
XFILLER_0_78 VPWR VGND VPWR VGND sky130_fd_sc_hd__decap_3
XFILLER_9_21 VPWR VGND VPWR VGND sky130_fd_sc_hd__decap_3
XFILLER_9_87 VPWR VGND VPWR VGND sky130_fd_sc_hd__decap_3
XFILLER_18_41 VPWR VGND VPWR VGND sky130_fd_sc_hd__decap_3
XFILLER_18_74 VPWR VGND VPWR VGND sky130_fd_sc_hd__decap_3
XFILLER_18_85 VPWR VGND VPWR VGND sky130_fd_sc_hd__decap_3
XFILLER_22_6 VPWR VGND VPWR VGND sky130_fd_sc_hd__decap_3
XFILLER_20_53 VPWR VGND VPWR VGND sky130_fd_sc_hd__decap_3
XFILLER_20_97 VPWR VGND VPWR VGND sky130_fd_sc_hd__decap_3
XFILLER_6_44 VPWR VGND VPWR VGND sky130_fd_sc_hd__decap_3
XFILLER_6_77 VPWR VGND VPWR VGND sky130_fd_sc_hd__decap_3
XFILLER_6_88 VPWR VGND VPWR VGND sky130_fd_sc_hd__decap_3
XFILLER_20_3 VPWR VGND VPWR VGND sky130_fd_sc_hd__decap_3
XFILLER_17_108 VPWR VGND VPWR VGND sky130_fd_sc_hd__decap_3
XFILLER_17_119 VPWR VGND VPWR VGND sky130_fd_sc_hd__decap_3
XFILLER_25_152 VPWR VGND VPWR VGND sky130_fd_sc_hd__decap_3
XFILLER_15_42 VPWR VGND VPWR VGND sky130_fd_sc_hd__decap_3
XFILLER_15_75 VPWR VGND VPWR VGND sky130_fd_sc_hd__decap_3
XFILLER_16_130 VPWR VGND VPWR VGND sky130_fd_sc_hd__decap_3
XFILLER_16_141 VPWR VGND VPWR VGND sky130_fd_sc_hd__decap_3
XFILLER_16_174 VPWR VGND VPWR VGND sky130_fd_sc_hd__decap_3
C0 u_buf/X ro_out 0.04371f
C1 VPWR u_inv3/A 0.42199f
C2 enable u_nand/A 0.00233f
C3 u_buf/A u_nand/A 0.02331f
C4 output2/a_27_47# u_inv3/A 0
C5 VPWR u_nand/Y 0.1471f
C6 ro_out input1/a_244_47# 0.00192f
C7 output2/a_244_47# u_nand/A 0.00597f
C8 u_buf/a_27_47# u_inv1/A 0.04705f
C9 enable u_inv3/A 0
C10 u_buf/A u_inv3/A 0.14716f
C11 output2/a_27_47# u_nand/Y 0.03268f
C12 enable u_nand/Y 0.0698f
C13 output2/a_244_47# u_inv3/A 0
C14 u_buf/A u_nand/Y 0.06083f
C15 u_nand/A u_inv1/A 0.00293f
C16 output2/a_355_47# u_nand/A 0.0082f
C17 u_nand/A u_nand/a_113_47# 0
C18 output2/a_244_47# u_nand/Y 0.01286f
C19 u_buf/a_27_47# u_inv3/A 0.02044f
C20 input1/a_27_47# u_inv2/A 0
C21 u_inv3/A u_inv1/A 0.20299f
C22 output2/a_355_47# u_inv3/A 0
C23 u_buf/X u_inv2/A 0.00441f
C24 u_buf/a_27_47# u_nand/Y 0.00752f
C25 u_nand/Y u_inv1/A 0.07277f
C26 u_nand/A u_inv3/A 0
C27 ro_out u_inv2/A 0.06578f
C28 output2/a_355_47# u_nand/Y 0.00732f
C29 u_nand/a_113_47# u_nand/Y 0
C30 VPWR input1/a_27_47# 0.05281f
C31 u_nand/A u_nand/Y 0.07929f
C32 VPWR u_buf/X 0.05601f
C33 output2/a_27_47# input1/a_27_47# 0.00213f
C34 VPWR ro_out 0.64387f
C35 u_buf/X output2/a_27_47# 0.03194f
C36 u_inv3/A u_nand/Y 0
C37 input1/a_27_47# enable 0.05028f
C38 output2/a_27_47# ro_out 0.04738f
C39 VPWR input1/a_244_47# 0.00687f
C40 u_buf/A u_buf/X 0.02278f
C41 output2/a_244_47# input1/a_27_47# 0.01004f
C42 ro_out enable 0.46975f
C43 u_buf/A ro_out 0
C44 u_buf/X output2/a_244_47# 0.00277f
C45 input1/a_244_47# enable 0.01004f
C46 output2/a_244_47# ro_out 0.04503f
C47 VPWR input1/a_355_47# 0.01522f
C48 input1/a_27_47# u_inv1/A 0.00718f
C49 u_buf/a_27_47# u_buf/X 0.04393f
C50 output2/a_355_47# input1/a_27_47# 0.00156f
C51 output2/a_244_47# input1/a_244_47# 0.0016f
C52 u_buf/X u_inv1/A 0.06579f
C53 u_buf/X output2/a_355_47# 0.00115f
C54 u_buf/a_27_47# ro_out 0.00239f
C55 input1/a_355_47# enable 0.00443f
C56 input1/a_27_47# u_nand/A 0.00188f
C57 ro_out u_inv1/A 0.15508f
C58 output2/a_355_47# ro_out 0.03597f
C59 ro_out u_nand/a_113_47# 0
C60 u_buf/X u_nand/A 0.00262f
C61 VPWR u_inv2/A 0.30591f
C62 input1/a_244_47# u_inv1/A 0
C63 output2/a_355_47# input1/a_244_47# 0.00826f
C64 ro_out u_nand/A 0.01792f
C65 input1/a_27_47# u_inv3/A 0
C66 u_buf/X u_inv3/A 0.01463f
C67 input1/a_244_47# u_nand/A 0.00385f
C68 input1/a_27_47# u_nand/Y 0.00977f
C69 u_buf/A u_inv2/A 0.06527f
C70 ro_out u_inv3/A 0.00365f
C71 input1/a_355_47# u_inv1/A 0
C72 u_buf/X u_nand/Y 0.04068f
C73 output2/a_355_47# input1/a_355_47# 0
C74 VPWR output2/a_27_47# 0.08666f
C75 ro_out u_nand/Y 0.22836f
C76 input1/a_355_47# u_nand/A 0.00398f
C77 input1/a_244_47# u_nand/Y 0.00353f
C78 VPWR enable 0.0274f
C79 u_buf/A VPWR 0.22084f
C80 u_buf/a_27_47# u_inv2/A 0.08982f
C81 output2/a_27_47# enable 0.00342f
C82 u_inv2/A u_inv1/A 0.21983f
C83 u_buf/A output2/a_27_47# 0.00339f
C84 VPWR output2/a_244_47# -0.0036f
C85 input1/a_355_47# u_nand/Y 0.00233f
C86 VPWR u_buf/a_27_47# 0.0068f
C87 output2/a_244_47# enable 0.00209f
C88 u_buf/A output2/a_244_47# 0
C89 VPWR u_inv1/A 0.28115f
C90 VPWR output2/a_355_47# -0.00207f
C91 u_buf/a_27_47# output2/a_27_47# 0
C92 u_inv3/A u_inv2/A 0.3169f
C93 output2/a_27_47# u_inv1/A 0
C94 VPWR u_nand/A 0.70704f
C95 u_buf/A u_buf/a_27_47# 0.04184f
C96 u_inv2/A u_nand/Y 0.02252f
C97 enable u_inv1/A 0.00503f
C98 u_buf/A u_inv1/A 0.21063f
C99 ro_out input1/a_27_47# 0
C100 output2/a_27_47# u_nand/A 0.00383f
C101 u_buf/A output2/a_355_47# 0
C102 u_buf/A u_nand/a_113_47# 0
C103 ro_out VGND 0.74644f
C104 output2/a_355_47# VGND 0.01354f
C105 output2/a_244_47# VGND 0.00549f
C106 output2/a_27_47# VGND 0.052f
C107 VPWR VGND -0.62691p
C108 u_buf/A VGND 0.32396f
C109 u_inv3/A VGND -0.0169f
C110 u_inv2/A VGND -0.06443f
C111 u_buf/X VGND 0.0088f
C112 u_buf/a_27_47# VGND -0.00142f
C113 u_inv1/A VGND -0.0226f
C114 u_nand/Y VGND 0.18235f
C115 u_nand/A VGND 0.6668f
C116 enable VGND 0.66705f
C117 input1/a_355_47# VGND 0.01281f
C118 input1/a_244_47# VGND 0.00201f
C119 input1/a_27_47# VGND 0.02948f
C120 u_nand/a_113_47# VGND 0
.ends
