* 5-stage Sky130 standard-cell ring oscillator

.lib "/foss/pdks/ciel/sky130/versions/7b70722e33c03fcb5dabcf4d479fb0822d9251c9/sky130A/libs.tech/ngspice/sky130.lib.spice" tt
.include "/foss/pdks/ciel/sky130/versions/7b70722e33c03fcb5dabcf4d479fb0822d9251c9/sky130A/libs.ref/sky130_fd_sc_hd/spice/sky130_fd_sc_hd.spice"

VDD VPWR 0 1.8
VSS VGND 0 0

* Pin order for sky130_fd_sc_hd__inv_1:
* A VGND VNB VPB VPWR Y

XINV0 n4 VGND VGND VPWR VPWR n0 sky130_fd_sc_hd__inv_1
XINV1 n0 VGND VGND VPWR VPWR n1 sky130_fd_sc_hd__inv_1
XINV2 n1 VGND VGND VPWR VPWR n2 sky130_fd_sc_hd__inv_1
XINV3 n2 VGND VGND VPWR VPWR n3 sky130_fd_sc_hd__inv_1
XINV4 n3 VGND VGND VPWR VPWR n4 sky130_fd_sc_hd__inv_1

.ic v(n0)=1.8 v(n1)=0 v(n2)=1.8 v(n3)=0 v(n4)=1.8

.tran 1p 200n uic

.measure tran period TRIG v(n0) VAL=0.9 RISE=20 TARG v(n0) VAL=0.9 RISE=21
.measure tran freq PARAM='1/period'

.control
run
plot v(n0)
print period
print freq
.endc

.end
